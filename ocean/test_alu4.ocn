; test_alu4.ocn - Verify 4-bit ALU (spot checks)
; Run: ocean -nograph < test_alu4.ocn

out = outfile("/home/v71349/analog-gradients/results/alu4_test.txt" "w")
fprintf(out "=== ALU4 Verification ===\n")
fprintf(out "Date: %s\n\n" getCurrentTime())

simulator('spectre)
openResults("/home/v71349/analog-gradients/results/alu4/alu4.raw")
selectResult("tran_test-tran")

vdd = 1.8
vth_low = 0.2 * vdd
vth_high = 0.8 * vdd

vy0 = v("y0")
vy1 = v("y1")
vy2 = v("y2")
vy3 = v("y3")
vcout = v("cout")

if(vy0 && vy1 && vy2 && vy3 && vcout then
    pass = t

    ; t=5ns: AND, A=0x5, B=0x3 -> Y=0x1
    fprintf(out "AND A=0x5 B=0x3 -> Y=0x1\n")
    v = value(vy0 5n)
    if(v > vth_high then fprintf(out "  y0 OK\n") else fprintf(out "  y0 FAIL\n") pass=nil)
    v = value(vy1 5n)
    if(v < vth_low then fprintf(out "  y1 OK\n") else fprintf(out "  y1 FAIL\n") pass=nil)
    v = value(vy2 5n)
    if(v < vth_low then fprintf(out "  y2 OK\n") else fprintf(out "  y2 FAIL\n") pass=nil)
    v = value(vy3 5n)
    if(v < vth_low then fprintf(out "  y3 OK\n") else fprintf(out "  y3 FAIL\n") pass=nil)

    ; t=15ns: OR, A=0xA, B=0x4 -> Y=0xE
    fprintf(out "OR  A=0xA B=0x4 -> Y=0xE\n")
    v = value(vy0 15n)
    if(v < vth_low then fprintf(out "  y0 OK\n") else fprintf(out "  y0 FAIL\n") pass=nil)
    v = value(vy1 15n)
    if(v > vth_high then fprintf(out "  y1 OK\n") else fprintf(out "  y1 FAIL\n") pass=nil)
    v = value(vy2 15n)
    if(v > vth_high then fprintf(out "  y2 OK\n") else fprintf(out "  y2 FAIL\n") pass=nil)
    v = value(vy3 15n)
    if(v > vth_high then fprintf(out "  y3 OK\n") else fprintf(out "  y3 FAIL\n") pass=nil)

    ; t=25ns: XOR, A=0x6, B=0x9 -> Y=0xF
    fprintf(out "XOR A=0x6 B=0x9 -> Y=0xF\n")
    v = value(vy0 25n)
    if(v > vth_high then fprintf(out "  y0 OK\n") else fprintf(out "  y0 FAIL\n") pass=nil)
    v = value(vy1 25n)
    if(v > vth_high then fprintf(out "  y1 OK\n") else fprintf(out "  y1 FAIL\n") pass=nil)
    v = value(vy2 25n)
    if(v > vth_high then fprintf(out "  y2 OK\n") else fprintf(out "  y2 FAIL\n") pass=nil)
    v = value(vy3 25n)
    if(v > vth_high then fprintf(out "  y3 OK\n") else fprintf(out "  y3 FAIL\n") pass=nil)

    ; t=35ns: ADD, A=0xF, B=0x1 -> Y=0x0, COUT=1
    fprintf(out "ADD A=0xF B=0x1 -> Y=0x0 COUT=1\n")
    v = value(vy0 35n)
    if(v < vth_low then fprintf(out "  y0 OK\n") else fprintf(out "  y0 FAIL\n") pass=nil)
    v = value(vy1 35n)
    if(v < vth_low then fprintf(out "  y1 OK\n") else fprintf(out "  y1 FAIL\n") pass=nil)
    v = value(vy2 35n)
    if(v < vth_low then fprintf(out "  y2 OK\n") else fprintf(out "  y2 FAIL\n") pass=nil)
    v = value(vy3 35n)
    if(v < vth_low then fprintf(out "  y3 OK\n") else fprintf(out "  y3 FAIL\n") pass=nil)
    v = value(vcout 35n)
    if(v > vth_high then fprintf(out "  cout OK\n") else fprintf(out "  cout FAIL\n") pass=nil)

    fprintf(out "\n")
    if(pass then
        fprintf(out "=== PASS: ALU4 verification (spot checks) ===\n")
    else
        fprintf(out "=== FAIL: ALU4 verification failed ===\n")
    )
else
    fprintf(out "ERROR: Could not read waveform data\n")
)

close(out)
printf("ALU4 test done.\n")
exit()
