; test_gpu_core.ocn - Verify GPU core (PE0 spot checks)
; Run: ocean -nograph < test_gpu_core.ocn

out = outfile("/home/v71349/analog-gradients/results/gpu_core_test.txt" "w")
fprintf(out "=== GPU CORE Verification ===\n")
fprintf(out "Date: %s\n\n" getCurrentTime())

simulator('spectre)
openResults("/home/v71349/analog-gradients/results/gpu_core/gpu_core.raw")
selectResult("tran_test-tran")

vdd = 1.8
vth_low = 0.2 * vdd
vth_high = 0.8 * vdd

pass = t

vy0_0 = v("y0_0")
vy0_1 = v("y0_1")
vy0_2 = v("y0_2")
vy0_3 = v("y0_3")
vcout0 = v("cout0")

if(vy0_0 && vy0_1 && vy0_2 && vy0_3 && vcout0 then
    ; t=5ns: AND -> Y=0x1
    v = value(vy0_0 5n)
    if(v > vth_high then t else pass=nil)
    v = value(vy0_1 5n)
    if(v < vth_low then t else pass=nil)
    v = value(vy0_2 5n)
    if(v < vth_low then t else pass=nil)
    v = value(vy0_3 5n)
    if(v < vth_low then t else pass=nil)

    ; t=15ns: OR -> Y=0xE
    v = value(vy0_0 15n)
    if(v < vth_low then t else pass=nil)
    v = value(vy0_1 15n)
    if(v > vth_high then t else pass=nil)
    v = value(vy0_2 15n)
    if(v > vth_high then t else pass=nil)
    v = value(vy0_3 15n)
    if(v > vth_high then t else pass=nil)

    ; t=25ns: XOR -> Y=0xF
    v = value(vy0_0 25n)
    if(v > vth_high then t else pass=nil)
    v = value(vy0_1 25n)
    if(v > vth_high then t else pass=nil)
    v = value(vy0_2 25n)
    if(v > vth_high then t else pass=nil)
    v = value(vy0_3 25n)
    if(v > vth_high then t else pass=nil)

    ; t=35ns: ADD -> Y=0x0, COUT=1
    v = value(vy0_0 35n)
    if(v < vth_low then t else pass=nil)
    v = value(vy0_1 35n)
    if(v < vth_low then t else pass=nil)
    v = value(vy0_2 35n)
    if(v < vth_low then t else pass=nil)
    v = value(vy0_3 35n)
    if(v < vth_low then t else pass=nil)
    v = value(vcout0 35n)
    if(v > vth_high then t else pass=nil)
else
    pass = nil
)

fprintf(out "\n")
if(pass then
    fprintf(out "=== PASS: GPU core verification (PE0 spot checks) ===\n")
else
    fprintf(out "=== FAIL: GPU core verification failed ===\n")
)

close(out)
printf("GPU core test done.\n")
exit()
