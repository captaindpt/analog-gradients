; export_competition_waveforms.ocn
; Export sampled waveform CSV files for competition visuals

simulator('spectre)

; ------------------------------------------------------------
; Synapse waveforms
; ------------------------------------------------------------
openResults("/home/v71349/analog-gradients/results/synapse/synapse.raw")
selectResult("tran_test-tran")

vpre = v("pre")
vpost = v("post")
vout = v("out")

fsyn = outfile("/home/v71349/analog-gradients/competition/data/synapse_waveform.csv" "w")
fprintf(fsyn "time_ns,pre,post,out\n")
ts = 0
while(ts <= 120n
    fprintf(fsyn "%.3f,%.6f,%.6f,%.6f\n" ts*1e9 value(vpre ts) value(vpost ts) value(vout ts))
    ts = ts + 500p
)
close(fsyn)

; ------------------------------------------------------------
; LIF neuron waveforms
; ------------------------------------------------------------
openResults("/home/v71349/analog-gradients/results/lif_neuron/lif_neuron.raw")
selectResult("tran_test-tran")

vmem = v("mem")
vspike = v("spike")
voutn = v("out")

flif = outfile("/home/v71349/analog-gradients/competition/data/lif_neuron_waveform.csv" "w")
fprintf(flif "time_ns,mem,spike,out\n")
ts = 0
while(ts <= 200n
    fprintf(flif "%.3f,%.6f,%.6f,%.6f\n" ts*1e9 value(vmem ts) value(vspike ts) value(voutn ts))
    ts = ts + 500p
)
close(flif)

; ------------------------------------------------------------
; Neuron tile waveforms
; ------------------------------------------------------------
openResults("/home/v71349/analog-gradients/results/neuron_tile/neuron_tile.raw")
selectResult("tran_test-tran")

vsyn = v("syn_post")
vtmem = v("mem")
vtspike = v("spike")

ftile = outfile("/home/v71349/analog-gradients/competition/data/neuron_tile_waveform.csv" "w")
fprintf(ftile "time_ns,syn_post,mem,spike\n")
ts = 0
while(ts <= 250n
    fprintf(ftile "%.3f,%.6f,%.6f,%.6f\n" ts*1e9 value(vsyn ts) value(vtmem ts) value(vtspike ts))
    ts = ts + 500p
)
close(ftile)

; ------------------------------------------------------------
; Neuro Tile4 spikes
; ------------------------------------------------------------
openResults("/home/v71349/analog-gradients/results/neuro_tile4/neuro_tile4.raw")
selectResult("tran_test-tran")

vsp0 = v("spike0")
vsp1 = v("spike1")
vsp2 = v("spike2")
vsp3 = v("spike3")
vmm0 = v("mem0")
vmm1 = v("mem1")
vmm2 = v("mem2")
vmm3 = v("mem3")

ftile4s = outfile("/home/v71349/analog-gradients/competition/data/neuro_tile4_spikes.csv" "w")
fprintf(ftile4s "time_ns,spike0,spike1,spike2,spike3\n")
ts = 0
while(ts <= 120n
    fprintf(ftile4s "%.3f,%.6f,%.6f,%.6f,%.6f\n"
        ts*1e9 value(vsp0 ts) value(vsp1 ts) value(vsp2 ts) value(vsp3 ts))
    ts = ts + 500p
)
close(ftile4s)

ftile4m = outfile("/home/v71349/analog-gradients/competition/data/neuro_tile4_mems.csv" "w")
fprintf(ftile4m "time_ns,mem0,mem1,mem2,mem3\n")
ts = 0
while(ts <= 120n
    fprintf(ftile4m "%.3f,%.6f,%.6f,%.6f,%.6f\n"
        ts*1e9 value(vmm0 ts) value(vmm1 ts) value(vmm2 ts) value(vmm3 ts))
    ts = ts + 500p
)
close(ftile4m)

; ------------------------------------------------------------
; Neuro Tile4 Coupled spikes/membranes
; ------------------------------------------------------------
openResults("/home/v71349/analog-gradients/results/neuro_tile4_coupled/neuro_tile4_coupled.raw")
selectResult("tran_test-tran")

vcsp0 = v("spike0")
vcsp1 = v("spike1")
vcsp2 = v("spike2")
vcsp3 = v("spike3")
vcm0 = v("mem0")
vcm1 = v("mem1")
vcm2 = v("mem2")
vcm3 = v("mem3")

fcsp = outfile("/home/v71349/analog-gradients/competition/data/neuro_tile4_coupled_spikes.csv" "w")
fprintf(fcsp "time_ns,spike0,spike1,spike2,spike3\n")
ts = 0
while(ts <= 120n
    fprintf(fcsp "%.3f,%.6f,%.6f,%.6f,%.6f\n"
        ts*1e9 value(vcsp0 ts) value(vcsp1 ts) value(vcsp2 ts) value(vcsp3 ts))
    ts = ts + 500p
)
close(fcsp)

fcm = outfile("/home/v71349/analog-gradients/competition/data/neuro_tile4_coupled_mems.csv" "w")
fprintf(fcm "time_ns,mem0,mem1,mem2,mem3\n")
ts = 0
while(ts <= 120n
    fprintf(fcm "%.3f,%.6f,%.6f,%.6f,%.6f\n"
        ts*1e9 value(vcm0 ts) value(vcm1 ts) value(vcm2 ts) value(vcm3 ts))
    ts = ts + 500p
)
close(fcm)

printf("Done. CSV waveforms exported to ~/analog-gradients/competition/data/\n")
exit()
