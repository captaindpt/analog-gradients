; test_neuro_tile4.ocn - Verify 4-neuron composition tile
; Run: ocean -nograph < test_neuro_tile4.ocn

out = outfile("/home/v71349/analog-gradients/results/neuro_tile4_test.txt" "w")
fprintf(out "=== Neuro Tile4 Verification ===\n")
fprintf(out "4-neuron synapse+LIF composition\n")
fprintf(out "Date: %s\n\n" getCurrentTime())

simulator('spectre)
openResults("/home/v71349/analog-gradients/results/neuro_tile4/neuro_tile4.raw")
selectResult("tran_test-tran")

vmem0 = v("mem0")
vmem1 = v("mem1")
vmem2 = v("mem2")
vmem3 = v("mem3")
vspk0 = v("spike0")
vspk1 = v("spike1")
vspk2 = v("spike2")
vspk3 = v("spike3")

if(vmem0 && vmem1 && vmem2 && vmem3 && vspk0 && vspk1 && vspk2 && vspk3 then
    pass = t
    fprintf(out "Waveform Analysis:\n")
    fprintf(out "==================\n\n")

    mem0_max = ymax(vmem0)
    mem1_max = ymax(vmem1)
    mem2_max = ymax(vmem2)
    mem3_max = ymax(vmem3)

    fprintf(out "Membrane maxima:\n")
    fprintf(out "  mem0: %.3f V\n" mem0_max)
    fprintf(out "  mem1: %.3f V\n" mem1_max)
    fprintf(out "  mem2: %.3f V\n" mem2_max)
    fprintf(out "  mem3: %.3f V\n\n" mem3_max)

    if(mem0_max <= 0.4 || mem1_max <= 0.4 || mem2_max <= 0.4 || mem3_max <= 0.4 then
        fprintf(out "FAIL: one or more membranes did not integrate sufficiently\n")
        pass = nil
    else
        fprintf(out "OK: all membrane nodes integrated synaptic drive\n")
    )

    spk0_min = ymin(vspk0)
    spk0_max = ymax(vspk0)
    spk1_min = ymin(vspk1)
    spk1_max = ymax(vspk1)
    spk2_min = ymin(vspk2)
    spk2_max = ymax(vspk2)
    spk3_min = ymin(vspk3)
    spk3_max = ymax(vspk3)

    th0 = (spk0_min + spk0_max) / 2
    th1 = (spk1_min + spk1_max) / 2
    th2 = (spk2_min + spk2_max) / 2
    th3 = (spk3_min + spk3_max) / 2

    count0 = 0
    count1 = 0
    count2 = 0
    count3 = 0
    first0 = nil
    first1 = nil
    first2 = nil
    first3 = nil

    ts0 = 1n
    prev0 = value(vspk0 ts0)
    ts0 = ts0 + 500p
    while(ts0 < 300n
        cur0 = value(vspk0 ts0)
        if(prev0 < th0 && cur0 > th0 then
            count0 = count0 + 1
            if(count0 == 1 then first0 = ts0)
        )
        prev0 = cur0
        ts0 = ts0 + 500p
    )

    ts1 = 1n
    prev1 = value(vspk1 ts1)
    ts1 = ts1 + 500p
    while(ts1 < 300n
        cur1 = value(vspk1 ts1)
        if(prev1 < th1 && cur1 > th1 then
            count1 = count1 + 1
            if(count1 == 1 then first1 = ts1)
        )
        prev1 = cur1
        ts1 = ts1 + 500p
    )

    ts2 = 1n
    prev2 = value(vspk2 ts2)
    ts2 = ts2 + 500p
    while(ts2 < 300n
        cur2 = value(vspk2 ts2)
        if(prev2 < th2 && cur2 > th2 then
            count2 = count2 + 1
            if(count2 == 1 then first2 = ts2)
        )
        prev2 = cur2
        ts2 = ts2 + 500p
    )

    ts3 = 1n
    prev3 = value(vspk3 ts3)
    ts3 = ts3 + 500p
    while(ts3 < 300n
        cur3 = value(vspk3 ts3)
        if(prev3 < th3 && cur3 > th3 then
            count3 = count3 + 1
            if(count3 == 1 then first3 = ts3)
        )
        prev3 = cur3
        ts3 = ts3 + 500p
    )

    fprintf(out "\nSpike pulse counts:\n")
    fprintf(out "  spike0: %d (min=%.3fV max=%.3fV)\n" count0 spk0_min spk0_max)
    fprintf(out "  spike1: %d (min=%.3fV max=%.3fV)\n" count1 spk1_min spk1_max)
    fprintf(out "  spike2: %d (min=%.3fV max=%.3fV)\n" count2 spk2_min spk2_max)
    fprintf(out "  spike3: %d (min=%.3fV max=%.3fV)\n\n" count3 spk3_min spk3_max)

    if(count0 < 1 || count1 < 1 || count2 < 1 || count3 < 1 then
        fprintf(out "FAIL: one or more neurons did not spike\n")
        pass = nil
    else
        fprintf(out "OK: all neurons produced spike pulses\n")
    )

    if(first0 && first1 && first2 && first3 then
        fprintf(out "First spike times (ns): %.1f, %.1f, %.1f, %.1f\n"
            first0*1e9 first1*1e9 first2*1e9 first3*1e9)

        if(first0 < first1 && first1 < first2 && first2 < first3 then
            fprintf(out "OK: channel staggering preserved in first spike timing\n")
        else
            fprintf(out "WARN: first spike order not strictly staggered\n")
        )
    )

    fprintf(out "\n")
    if(pass then
        fprintf(out "=== PASS: Neuro Tile4 verified ===\n")
    else
        fprintf(out "=== FAIL: Neuro Tile4 verification failed ===\n")
    )
else
    fprintf(out "ERROR: Could not read waveform data\n")
)

close(out)
printf("Done. Results in: ~/analog-gradients/results/neuro_tile4_test.txt\n")
exit()
