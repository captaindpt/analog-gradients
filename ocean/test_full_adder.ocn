; test_full_adder.ocn - Verify full adder truth table
; Run: ocean -nograph < test_full_adder.ocn

out = outfile("/home/v71349/analog-gradients/results/full_adder_test.txt" "w")
fprintf(out "=== FULL ADDER Verification ===\n")
fprintf(out "Date: %s\n\n" getCurrentTime())

simulator('spectre)
openResults("/home/v71349/analog-gradients/results/full_adder/full_adder.raw")
selectResult("tran_test-tran")

vdd = 1.8
vth_low = 0.2 * vdd
vth_high = 0.8 * vdd

vsum = v("sum")
vcar = v("cout")

if(vsum && vcar then
    pass = t

    ; 000 -> SUM=0, COUT=0
    v = value(vsum 5n)
    fprintf(out "A=0, B=0, CIN=0 SUM=%.3f " v)
    if(v < vth_low then fprintf(out "[PASS]\n") else fprintf(out "[FAIL]\n") pass=nil)
    v = value(vcar 5n)
    fprintf(out "A=0, B=0, CIN=0 COUT=%.3f " v)
    if(v < vth_low then fprintf(out "[PASS]\n") else fprintf(out "[FAIL]\n") pass=nil)

    ; 100 -> SUM=1, COUT=0
    v = value(vsum 15n)
    fprintf(out "A=1, B=0, CIN=0 SUM=%.3f " v)
    if(v > vth_high then fprintf(out "[PASS]\n") else fprintf(out "[FAIL]\n") pass=nil)
    v = value(vcar 15n)
    fprintf(out "A=1, B=0, CIN=0 COUT=%.3f " v)
    if(v < vth_low then fprintf(out "[PASS]\n") else fprintf(out "[FAIL]\n") pass=nil)

    ; 010 -> SUM=1, COUT=0
    v = value(vsum 25n)
    fprintf(out "A=0, B=1, CIN=0 SUM=%.3f " v)
    if(v > vth_high then fprintf(out "[PASS]\n") else fprintf(out "[FAIL]\n") pass=nil)
    v = value(vcar 25n)
    fprintf(out "A=0, B=1, CIN=0 COUT=%.3f " v)
    if(v < vth_low then fprintf(out "[PASS]\n") else fprintf(out "[FAIL]\n") pass=nil)

    ; 110 -> SUM=0, COUT=1
    v = value(vsum 35n)
    fprintf(out "A=1, B=1, CIN=0 SUM=%.3f " v)
    if(v < vth_low then fprintf(out "[PASS]\n") else fprintf(out "[FAIL]\n") pass=nil)
    v = value(vcar 35n)
    fprintf(out "A=1, B=1, CIN=0 COUT=%.3f " v)
    if(v > vth_high then fprintf(out "[PASS]\n") else fprintf(out "[FAIL]\n") pass=nil)

    ; 001 -> SUM=1, COUT=0
    v = value(vsum 45n)
    fprintf(out "A=0, B=0, CIN=1 SUM=%.3f " v)
    if(v > vth_high then fprintf(out "[PASS]\n") else fprintf(out "[FAIL]\n") pass=nil)
    v = value(vcar 45n)
    fprintf(out "A=0, B=0, CIN=1 COUT=%.3f " v)
    if(v < vth_low then fprintf(out "[PASS]\n") else fprintf(out "[FAIL]\n") pass=nil)

    ; 101 -> SUM=0, COUT=1
    v = value(vsum 55n)
    fprintf(out "A=1, B=0, CIN=1 SUM=%.3f " v)
    if(v < vth_low then fprintf(out "[PASS]\n") else fprintf(out "[FAIL]\n") pass=nil)
    v = value(vcar 55n)
    fprintf(out "A=1, B=0, CIN=1 COUT=%.3f " v)
    if(v > vth_high then fprintf(out "[PASS]\n") else fprintf(out "[FAIL]\n") pass=nil)

    ; 011 -> SUM=0, COUT=1
    v = value(vsum 65n)
    fprintf(out "A=0, B=1, CIN=1 SUM=%.3f " v)
    if(v < vth_low then fprintf(out "[PASS]\n") else fprintf(out "[FAIL]\n") pass=nil)
    v = value(vcar 65n)
    fprintf(out "A=0, B=1, CIN=1 COUT=%.3f " v)
    if(v > vth_high then fprintf(out "[PASS]\n") else fprintf(out "[FAIL]\n") pass=nil)

    ; 111 -> SUM=1, COUT=1
    v = value(vsum 75n)
    fprintf(out "A=1, B=1, CIN=1 SUM=%.3f " v)
    if(v > vth_high then fprintf(out "[PASS]\n") else fprintf(out "[FAIL]\n") pass=nil)
    v = value(vcar 75n)
    fprintf(out "A=1, B=1, CIN=1 COUT=%.3f " v)
    if(v > vth_high then fprintf(out "[PASS]\n") else fprintf(out "[FAIL]\n") pass=nil)

    fprintf(out "\n")
    if(pass then
        fprintf(out "=== PASS: FULL ADDER truth table verified ===\n")
    else
        fprintf(out "=== FAIL: FULL ADDER verification failed ===\n")
    )
else
    fprintf(out "ERROR: Could not read waveform data\n")
)

close(out)
printf("FULL ADDER test done.\n")
exit()
