; test_lif_neuron.ocn - Verify LIF neuron spiking behavior
; Run: ocean -nograph < test_lif_neuron.ocn

out = outfile("results/lif_neuron_test.txt" "w")
fprintf(out "=== LIF Neuron Verification ===\n")
fprintf(out "Leaky Integrate-and-Fire Analog Neuron\n")
fprintf(out "Date: %s\n\n" getCurrentTime())

simulator('spectre)
openResults("results/lif_neuron/lif_neuron.raw")

selectResult("tran_test-tran")

fprintf(out "Test Parameters:\n")
fprintf(out "  Membrane capacitance: 1pF\n")
fprintf(out "  Leak resistance: 10M ohm\n")
fprintf(out "  Time constant (tau): 10us\n")
fprintf(out "  Input current: 500uA pulses\n\n")

; Get waveforms
vmem = v("mem")
vspike = v("spike")
vout = v("out")

vdd = 1.8
vth_spike = 0.9  ; Threshold for detecting spike (Vdd/2)

if(vmem && vspike then
    fprintf(out "Waveform Analysis:\n")
    fprintf(out "==================\n\n")

    ; Check membrane voltage behavior
    ; Should see charging during input, decay between inputs

    ; Sample at key times
    ; t=0-5n: no input yet, mem should be low
    ; t=5-7n: first input pulse, mem charging
    ; t=10n: after first pulse, check if mem charged
    ; t=20n: before second pulse, check decay

    vmem_t0 = value(vmem 1n)
    vmem_t10 = value(vmem 10n)
    vmem_t15 = value(vmem 15n)
    vmem_t25 = value(vmem 25n)

    fprintf(out "Membrane voltage samples:\n")
    fprintf(out "  t=1ns  (before input):  Vmem = %.3f V\n" vmem_t0)
    fprintf(out "  t=10ns (after 1st pulse): Vmem = %.3f V\n" vmem_t10)
    fprintf(out "  t=15ns (decaying):       Vmem = %.3f V\n" vmem_t15)
    fprintf(out "  t=25ns (after 2nd pulse): Vmem = %.3f V\n\n" vmem_t25)

    ; Count spikes: look for rising edges in spike signal
    ; A spike is when vspike crosses vth_spike going up
    spike_count = 0
    spike_times = nil

    ; Simple spike detection: sample at regular intervals
    ts = 1n
    prev_spike = 0
    while(ts < 200n
        curr_spike = value(vspike ts)
        ; Detect rising edge
        if(prev_spike < vth_spike && curr_spike > vth_spike then
            spike_count = spike_count + 1
            spike_times = cons(ts spike_times)
        )
        prev_spike = curr_spike
        ts = ts + 500p
    )

    fprintf(out "Spike Detection:\n")
    fprintf(out "  Total spikes detected: %d\n" spike_count)

    if(spike_times then
        fprintf(out "  Spike times: ")
        foreach(st reverse(spike_times)
            fprintf(out "%.0fns " st*1e9)
        )
        fprintf(out "\n")
        first_spike_time = car(reverse(spike_times))
        fprintf(out "  First spike time: %.3f ns\n" first_spike_time*1e9)
    )

    ; Calculate inter-spike interval if multiple spikes
    if(spike_count >= 2 then
        times_list = reverse(spike_times)
        t1 = car(times_list)
        t2 = cadr(times_list)
        isi = (t2 - t1) * 1e9
        freq = 1 / (t2 - t1) / 1e6  ; MHz
        fprintf(out "  Inter-spike interval: %.1f ns\n" isi)
        fprintf(out "  Spike frequency: %.1f MHz\n" freq)
    )

    fprintf(out "\n")

    ; Verification criteria
    pass = t

    ; 1. Membrane should charge above 0.3V at some point
    vmem_max = ymax(vmem)
    fprintf(out "Verification:\n")
    fprintf(out "  Max membrane voltage: %.3f V\n" vmem_max)
    if(vmem_max > 0.3 then
        fprintf(out "  OK: Membrane charges above 0.3V\n")
    else
        fprintf(out "  FAIL: Membrane not charging properly\n")
        pass = nil
    )

    ; 2. Should see at least one spike
    if(spike_count >= 1 then
        fprintf(out "  OK: At least one spike detected\n")
    else
        fprintf(out "  FAIL: No spikes detected\n")
        pass = nil
    )

    ; 3. Membrane should reset after spike (not stay high)
    ; Require a meaningful drop from peak after the first spike
    if(spike_times then
        first_spike_time = car(reverse(spike_times))
        vmem_first_spike = value(vmem first_spike_time)
        vmem_after_spike = value(vmem first_spike_time + 5n)
        vmem_drop = vmem_first_spike - vmem_after_spike
        fprintf(out "  Vmem at first spike: %.3f V\n" vmem_first_spike)
        fprintf(out "  Vmem 5ns after first spike: %.3f V\n" vmem_after_spike)
        if(vmem_drop > 0.15 then
            fprintf(out "  OK: Membrane resets after spike (drop=%.3f V)\n" vmem_drop)
        else
            fprintf(out "  FAIL: Membrane reset drop too small (drop=%.3f V)\n" vmem_drop)
            pass = nil
        )
    )

    fprintf(out "\n")
    if(pass then
        fprintf(out "=== PASS: LIF Neuron exhibits spiking behavior ===\n")
    else
        fprintf(out "=== FAIL: LIF Neuron verification failed ===\n")
    )
else
    fprintf(out "ERROR: Could not read waveform data\n")
    fprintf(out "Available outputs:\n")
    foreach(o outputs() fprintf(out "  %s\n" o))
)

close(out)
printf("Done. Results in: ~/analog-gradients/results/lif_neuron_test.txt\n")
exit()
