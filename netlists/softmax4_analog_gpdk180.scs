// softmax4_analog_gpdk180.scs - GPDK180-compatible analog softmax (current-mode)
// NOTE: Uses GPDK180 nmos1 devices with a fixed tail current.
// Outputs are taken as Vout_i = vdd - I_i * rout (use harness scaling to compare).

simulator lang=spectre
global 0

parameters vdd_val=1.8
parameters in0=0 in1=0 in2=0 in3=0
parameters itail=100u rout=10k
parameters w_exp=2u l_exp=0.18u

include "/CMC/kits/cadence/GPDK180/gpdk180_v3.3/models/spectre/gpdk.scs" section=NN

V_VDD (vdd 0) vsource dc=vdd_val

// Input voltages (logits)
V_IN0 (vin0 0) vsource dc=in0
V_IN1 (vin1 0) vsource dc=in1
V_IN2 (vin2 0) vsource dc=in2
V_IN3 (vin3 0) vsource dc=in3

// Tail current sink (sets total current)
I_TAIL (vsum 0) isource dc=itail

// Exponential branch devices (subthreshold region)
XEXP0 (out0 vin0 vsum 0) nmos1 w=w_exp l=l_exp
XEXP1 (out1 vin1 vsum 0) nmos1 w=w_exp l=l_exp
XEXP2 (out2 vin2 vsum 0) nmos1 w=w_exp l=l_exp
XEXP3 (out3 vin3 vsum 0) nmos1 w=w_exp l=l_exp

// Load resistors to convert current -> voltage
R0 (vdd out0) resistor r=rout
R1 (vdd out1) resistor r=rout
R2 (vdd out2) resistor r=rout
R3 (vdd out3) resistor r=rout

C0 (out0 0) capacitor c=1p
C1 (out1 0) capacitor c=1p
C2 (out2 0) capacitor c=1p
C3 (out3 0) capacitor c=1p

tran_test tran stop=50n
save vin0 vin1 vin2 vin3 out0 out1 out2 out3 vsum vdd V_VDD:p
