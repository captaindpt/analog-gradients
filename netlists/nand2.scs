// nand2.scs - 2-input CMOS NAND Gate
// Truth table: OUT = ~(A & B)
//   A B | OUT
//   0 0 | 1
//   0 1 | 1
//   1 0 | 1
//   1 1 | 0
// Run: spectre nand2.scs -raw nand2.raw

simulator lang=spectre

parameters vdd_val=1.8

// MOSFET Models
model nch mos1 type=n vto=0.4 kp=120u
model pch mos1 type=p vto=-0.4 kp=40u

// Supply
V_VDD (vdd 0) vsource dc=vdd_val

// Inputs - cycle through all 4 combinations
// A: period=20n (0-10n=0, 10-20n=1)
// B: period=40n (0-20n=0, 20-40n=1)
// t=5ns:  A=0, B=0
// t=15ns: A=1, B=0
// t=25ns: A=0, B=1
// t=35ns: A=1, B=1
V_A (a 0) vsource type=pulse val0=0 val1=vdd_val delay=10n rise=100p fall=100p width=10n period=20n
V_B (b 0) vsource type=pulse val0=0 val1=vdd_val delay=20n rise=100p fall=100p width=20n period=40n

// NAND2 Gate
// Parallel PMOS (pull-up) - either A or B LOW turns on pull-up
MP0 (out a vdd vdd) pch w=2u l=1u
MP1 (out b vdd vdd) pch w=2u l=1u

// Series NMOS (pull-down) - both A AND B HIGH needed to pull down
// Wider channel for series resistance
MN0 (out a mid 0) nch w=2u l=1u
MN1 (mid b 0 0) nch w=2u l=1u

// Analysis
tran_test tran stop=80n

save out a b
