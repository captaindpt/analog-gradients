// matmul4x4_binary_neuro.scs - Binary 4x4 matmul transistor checkpoint (neuro path)
// Partial products via coincidence-like current summation, output via membrane integration.

simulator lang=spectre

parameters vdd_val=1.8 iin_amp=220u cmul=1p rmul=20k csum=700f rsum_leak=15M rsum_in=6k
parameters a00=1 a01=0 a02=1 a03=1 a10=0 a11=1 a12=1 a13=0 a20=1 a21=1 a22=0 a23=1 a30=1 a31=0 a32=0 a33=1 b00=1 b01=1 b02=0 b03=1 b10=0 b11=1 b12=1 b13=0 b20=1 b21=0 b22=1 b23=1 b30=0 b31=1 b32=1 b33=1

model nch mos1 type=n vto=0.0 kp=120u
model pch mos1 type=p vto=0.0 kp=40u
model nch_cmp mos1 type=n vto=0.5 kp=120u
model pch_cmp mos1 type=p vto=-0.5 kp=40u

V_VDD (vdd 0) vsource dc=vdd_val

// p_0_0_0 = a00 * b00
I_P_0_0_0_A (vdd mem_p_0_0_0) isource type=pulse val0=0 val1=a00*iin_amp delay=10n rise=100p fall=100p width=2n period=200n
I_P_0_0_0_B (vdd mem_p_0_0_0) isource type=pulse val0=0 val1=b00*iin_amp delay=10n rise=100p fall=100p width=2n period=200n
C_P_0_0_0 (mem_p_0_0_0 0) capacitor c=cmul
R_P_0_0_0 (mem_p_0_0_0 0) resistor r=rmul
MP_P_0_0_0_1 (p_0_0_0_n mem_p_0_0_0 vdd vdd) pch_cmp w=2u l=1u
MN_P_0_0_0_1 (p_0_0_0_n mem_p_0_0_0 0 0) nch_cmp w=1u l=1u
MP_P_0_0_0_2 (p_0_0_0 p_0_0_0_n vdd vdd) pch w=2u l=1u
MN_P_0_0_0_2 (p_0_0_0 p_0_0_0_n 0 0) nch w=1u l=1u

// p_0_0_1 = a01 * b10
I_P_0_0_1_A (vdd mem_p_0_0_1) isource type=pulse val0=0 val1=a01*iin_amp delay=10n rise=100p fall=100p width=2n period=200n
I_P_0_0_1_B (vdd mem_p_0_0_1) isource type=pulse val0=0 val1=b10*iin_amp delay=10n rise=100p fall=100p width=2n period=200n
C_P_0_0_1 (mem_p_0_0_1 0) capacitor c=cmul
R_P_0_0_1 (mem_p_0_0_1 0) resistor r=rmul
MP_P_0_0_1_1 (p_0_0_1_n mem_p_0_0_1 vdd vdd) pch_cmp w=2u l=1u
MN_P_0_0_1_1 (p_0_0_1_n mem_p_0_0_1 0 0) nch_cmp w=1u l=1u
MP_P_0_0_1_2 (p_0_0_1 p_0_0_1_n vdd vdd) pch w=2u l=1u
MN_P_0_0_1_2 (p_0_0_1 p_0_0_1_n 0 0) nch w=1u l=1u

// p_0_0_2 = a02 * b20
I_P_0_0_2_A (vdd mem_p_0_0_2) isource type=pulse val0=0 val1=a02*iin_amp delay=10n rise=100p fall=100p width=2n period=200n
I_P_0_0_2_B (vdd mem_p_0_0_2) isource type=pulse val0=0 val1=b20*iin_amp delay=10n rise=100p fall=100p width=2n period=200n
C_P_0_0_2 (mem_p_0_0_2 0) capacitor c=cmul
R_P_0_0_2 (mem_p_0_0_2 0) resistor r=rmul
MP_P_0_0_2_1 (p_0_0_2_n mem_p_0_0_2 vdd vdd) pch_cmp w=2u l=1u
MN_P_0_0_2_1 (p_0_0_2_n mem_p_0_0_2 0 0) nch_cmp w=1u l=1u
MP_P_0_0_2_2 (p_0_0_2 p_0_0_2_n vdd vdd) pch w=2u l=1u
MN_P_0_0_2_2 (p_0_0_2 p_0_0_2_n 0 0) nch w=1u l=1u

// p_0_0_3 = a03 * b30
I_P_0_0_3_A (vdd mem_p_0_0_3) isource type=pulse val0=0 val1=a03*iin_amp delay=10n rise=100p fall=100p width=2n period=200n
I_P_0_0_3_B (vdd mem_p_0_0_3) isource type=pulse val0=0 val1=b30*iin_amp delay=10n rise=100p fall=100p width=2n period=200n
C_P_0_0_3 (mem_p_0_0_3 0) capacitor c=cmul
R_P_0_0_3 (mem_p_0_0_3 0) resistor r=rmul
MP_P_0_0_3_1 (p_0_0_3_n mem_p_0_0_3 vdd vdd) pch_cmp w=2u l=1u
MN_P_0_0_3_1 (p_0_0_3_n mem_p_0_0_3 0 0) nch_cmp w=1u l=1u
MP_P_0_0_3_2 (p_0_0_3 p_0_0_3_n vdd vdd) pch w=2u l=1u
MN_P_0_0_3_2 (p_0_0_3 p_0_0_3_n 0 0) nch w=1u l=1u

// p_0_1_0 = a00 * b01
I_P_0_1_0_A (vdd mem_p_0_1_0) isource type=pulse val0=0 val1=a00*iin_amp delay=10n rise=100p fall=100p width=2n period=200n
I_P_0_1_0_B (vdd mem_p_0_1_0) isource type=pulse val0=0 val1=b01*iin_amp delay=10n rise=100p fall=100p width=2n period=200n
C_P_0_1_0 (mem_p_0_1_0 0) capacitor c=cmul
R_P_0_1_0 (mem_p_0_1_0 0) resistor r=rmul
MP_P_0_1_0_1 (p_0_1_0_n mem_p_0_1_0 vdd vdd) pch_cmp w=2u l=1u
MN_P_0_1_0_1 (p_0_1_0_n mem_p_0_1_0 0 0) nch_cmp w=1u l=1u
MP_P_0_1_0_2 (p_0_1_0 p_0_1_0_n vdd vdd) pch w=2u l=1u
MN_P_0_1_0_2 (p_0_1_0 p_0_1_0_n 0 0) nch w=1u l=1u

// p_0_1_1 = a01 * b11
I_P_0_1_1_A (vdd mem_p_0_1_1) isource type=pulse val0=0 val1=a01*iin_amp delay=10n rise=100p fall=100p width=2n period=200n
I_P_0_1_1_B (vdd mem_p_0_1_1) isource type=pulse val0=0 val1=b11*iin_amp delay=10n rise=100p fall=100p width=2n period=200n
C_P_0_1_1 (mem_p_0_1_1 0) capacitor c=cmul
R_P_0_1_1 (mem_p_0_1_1 0) resistor r=rmul
MP_P_0_1_1_1 (p_0_1_1_n mem_p_0_1_1 vdd vdd) pch_cmp w=2u l=1u
MN_P_0_1_1_1 (p_0_1_1_n mem_p_0_1_1 0 0) nch_cmp w=1u l=1u
MP_P_0_1_1_2 (p_0_1_1 p_0_1_1_n vdd vdd) pch w=2u l=1u
MN_P_0_1_1_2 (p_0_1_1 p_0_1_1_n 0 0) nch w=1u l=1u

// p_0_1_2 = a02 * b21
I_P_0_1_2_A (vdd mem_p_0_1_2) isource type=pulse val0=0 val1=a02*iin_amp delay=10n rise=100p fall=100p width=2n period=200n
I_P_0_1_2_B (vdd mem_p_0_1_2) isource type=pulse val0=0 val1=b21*iin_amp delay=10n rise=100p fall=100p width=2n period=200n
C_P_0_1_2 (mem_p_0_1_2 0) capacitor c=cmul
R_P_0_1_2 (mem_p_0_1_2 0) resistor r=rmul
MP_P_0_1_2_1 (p_0_1_2_n mem_p_0_1_2 vdd vdd) pch_cmp w=2u l=1u
MN_P_0_1_2_1 (p_0_1_2_n mem_p_0_1_2 0 0) nch_cmp w=1u l=1u
MP_P_0_1_2_2 (p_0_1_2 p_0_1_2_n vdd vdd) pch w=2u l=1u
MN_P_0_1_2_2 (p_0_1_2 p_0_1_2_n 0 0) nch w=1u l=1u

// p_0_1_3 = a03 * b31
I_P_0_1_3_A (vdd mem_p_0_1_3) isource type=pulse val0=0 val1=a03*iin_amp delay=10n rise=100p fall=100p width=2n period=200n
I_P_0_1_3_B (vdd mem_p_0_1_3) isource type=pulse val0=0 val1=b31*iin_amp delay=10n rise=100p fall=100p width=2n period=200n
C_P_0_1_3 (mem_p_0_1_3 0) capacitor c=cmul
R_P_0_1_3 (mem_p_0_1_3 0) resistor r=rmul
MP_P_0_1_3_1 (p_0_1_3_n mem_p_0_1_3 vdd vdd) pch_cmp w=2u l=1u
MN_P_0_1_3_1 (p_0_1_3_n mem_p_0_1_3 0 0) nch_cmp w=1u l=1u
MP_P_0_1_3_2 (p_0_1_3 p_0_1_3_n vdd vdd) pch w=2u l=1u
MN_P_0_1_3_2 (p_0_1_3 p_0_1_3_n 0 0) nch w=1u l=1u

// p_0_2_0 = a00 * b02
I_P_0_2_0_A (vdd mem_p_0_2_0) isource type=pulse val0=0 val1=a00*iin_amp delay=10n rise=100p fall=100p width=2n period=200n
I_P_0_2_0_B (vdd mem_p_0_2_0) isource type=pulse val0=0 val1=b02*iin_amp delay=10n rise=100p fall=100p width=2n period=200n
C_P_0_2_0 (mem_p_0_2_0 0) capacitor c=cmul
R_P_0_2_0 (mem_p_0_2_0 0) resistor r=rmul
MP_P_0_2_0_1 (p_0_2_0_n mem_p_0_2_0 vdd vdd) pch_cmp w=2u l=1u
MN_P_0_2_0_1 (p_0_2_0_n mem_p_0_2_0 0 0) nch_cmp w=1u l=1u
MP_P_0_2_0_2 (p_0_2_0 p_0_2_0_n vdd vdd) pch w=2u l=1u
MN_P_0_2_0_2 (p_0_2_0 p_0_2_0_n 0 0) nch w=1u l=1u

// p_0_2_1 = a01 * b12
I_P_0_2_1_A (vdd mem_p_0_2_1) isource type=pulse val0=0 val1=a01*iin_amp delay=10n rise=100p fall=100p width=2n period=200n
I_P_0_2_1_B (vdd mem_p_0_2_1) isource type=pulse val0=0 val1=b12*iin_amp delay=10n rise=100p fall=100p width=2n period=200n
C_P_0_2_1 (mem_p_0_2_1 0) capacitor c=cmul
R_P_0_2_1 (mem_p_0_2_1 0) resistor r=rmul
MP_P_0_2_1_1 (p_0_2_1_n mem_p_0_2_1 vdd vdd) pch_cmp w=2u l=1u
MN_P_0_2_1_1 (p_0_2_1_n mem_p_0_2_1 0 0) nch_cmp w=1u l=1u
MP_P_0_2_1_2 (p_0_2_1 p_0_2_1_n vdd vdd) pch w=2u l=1u
MN_P_0_2_1_2 (p_0_2_1 p_0_2_1_n 0 0) nch w=1u l=1u

// p_0_2_2 = a02 * b22
I_P_0_2_2_A (vdd mem_p_0_2_2) isource type=pulse val0=0 val1=a02*iin_amp delay=10n rise=100p fall=100p width=2n period=200n
I_P_0_2_2_B (vdd mem_p_0_2_2) isource type=pulse val0=0 val1=b22*iin_amp delay=10n rise=100p fall=100p width=2n period=200n
C_P_0_2_2 (mem_p_0_2_2 0) capacitor c=cmul
R_P_0_2_2 (mem_p_0_2_2 0) resistor r=rmul
MP_P_0_2_2_1 (p_0_2_2_n mem_p_0_2_2 vdd vdd) pch_cmp w=2u l=1u
MN_P_0_2_2_1 (p_0_2_2_n mem_p_0_2_2 0 0) nch_cmp w=1u l=1u
MP_P_0_2_2_2 (p_0_2_2 p_0_2_2_n vdd vdd) pch w=2u l=1u
MN_P_0_2_2_2 (p_0_2_2 p_0_2_2_n 0 0) nch w=1u l=1u

// p_0_2_3 = a03 * b32
I_P_0_2_3_A (vdd mem_p_0_2_3) isource type=pulse val0=0 val1=a03*iin_amp delay=10n rise=100p fall=100p width=2n period=200n
I_P_0_2_3_B (vdd mem_p_0_2_3) isource type=pulse val0=0 val1=b32*iin_amp delay=10n rise=100p fall=100p width=2n period=200n
C_P_0_2_3 (mem_p_0_2_3 0) capacitor c=cmul
R_P_0_2_3 (mem_p_0_2_3 0) resistor r=rmul
MP_P_0_2_3_1 (p_0_2_3_n mem_p_0_2_3 vdd vdd) pch_cmp w=2u l=1u
MN_P_0_2_3_1 (p_0_2_3_n mem_p_0_2_3 0 0) nch_cmp w=1u l=1u
MP_P_0_2_3_2 (p_0_2_3 p_0_2_3_n vdd vdd) pch w=2u l=1u
MN_P_0_2_3_2 (p_0_2_3 p_0_2_3_n 0 0) nch w=1u l=1u

// p_0_3_0 = a00 * b03
I_P_0_3_0_A (vdd mem_p_0_3_0) isource type=pulse val0=0 val1=a00*iin_amp delay=10n rise=100p fall=100p width=2n period=200n
I_P_0_3_0_B (vdd mem_p_0_3_0) isource type=pulse val0=0 val1=b03*iin_amp delay=10n rise=100p fall=100p width=2n period=200n
C_P_0_3_0 (mem_p_0_3_0 0) capacitor c=cmul
R_P_0_3_0 (mem_p_0_3_0 0) resistor r=rmul
MP_P_0_3_0_1 (p_0_3_0_n mem_p_0_3_0 vdd vdd) pch_cmp w=2u l=1u
MN_P_0_3_0_1 (p_0_3_0_n mem_p_0_3_0 0 0) nch_cmp w=1u l=1u
MP_P_0_3_0_2 (p_0_3_0 p_0_3_0_n vdd vdd) pch w=2u l=1u
MN_P_0_3_0_2 (p_0_3_0 p_0_3_0_n 0 0) nch w=1u l=1u

// p_0_3_1 = a01 * b13
I_P_0_3_1_A (vdd mem_p_0_3_1) isource type=pulse val0=0 val1=a01*iin_amp delay=10n rise=100p fall=100p width=2n period=200n
I_P_0_3_1_B (vdd mem_p_0_3_1) isource type=pulse val0=0 val1=b13*iin_amp delay=10n rise=100p fall=100p width=2n period=200n
C_P_0_3_1 (mem_p_0_3_1 0) capacitor c=cmul
R_P_0_3_1 (mem_p_0_3_1 0) resistor r=rmul
MP_P_0_3_1_1 (p_0_3_1_n mem_p_0_3_1 vdd vdd) pch_cmp w=2u l=1u
MN_P_0_3_1_1 (p_0_3_1_n mem_p_0_3_1 0 0) nch_cmp w=1u l=1u
MP_P_0_3_1_2 (p_0_3_1 p_0_3_1_n vdd vdd) pch w=2u l=1u
MN_P_0_3_1_2 (p_0_3_1 p_0_3_1_n 0 0) nch w=1u l=1u

// p_0_3_2 = a02 * b23
I_P_0_3_2_A (vdd mem_p_0_3_2) isource type=pulse val0=0 val1=a02*iin_amp delay=10n rise=100p fall=100p width=2n period=200n
I_P_0_3_2_B (vdd mem_p_0_3_2) isource type=pulse val0=0 val1=b23*iin_amp delay=10n rise=100p fall=100p width=2n period=200n
C_P_0_3_2 (mem_p_0_3_2 0) capacitor c=cmul
R_P_0_3_2 (mem_p_0_3_2 0) resistor r=rmul
MP_P_0_3_2_1 (p_0_3_2_n mem_p_0_3_2 vdd vdd) pch_cmp w=2u l=1u
MN_P_0_3_2_1 (p_0_3_2_n mem_p_0_3_2 0 0) nch_cmp w=1u l=1u
MP_P_0_3_2_2 (p_0_3_2 p_0_3_2_n vdd vdd) pch w=2u l=1u
MN_P_0_3_2_2 (p_0_3_2 p_0_3_2_n 0 0) nch w=1u l=1u

// p_0_3_3 = a03 * b33
I_P_0_3_3_A (vdd mem_p_0_3_3) isource type=pulse val0=0 val1=a03*iin_amp delay=10n rise=100p fall=100p width=2n period=200n
I_P_0_3_3_B (vdd mem_p_0_3_3) isource type=pulse val0=0 val1=b33*iin_amp delay=10n rise=100p fall=100p width=2n period=200n
C_P_0_3_3 (mem_p_0_3_3 0) capacitor c=cmul
R_P_0_3_3 (mem_p_0_3_3 0) resistor r=rmul
MP_P_0_3_3_1 (p_0_3_3_n mem_p_0_3_3 vdd vdd) pch_cmp w=2u l=1u
MN_P_0_3_3_1 (p_0_3_3_n mem_p_0_3_3 0 0) nch_cmp w=1u l=1u
MP_P_0_3_3_2 (p_0_3_3 p_0_3_3_n vdd vdd) pch w=2u l=1u
MN_P_0_3_3_2 (p_0_3_3 p_0_3_3_n 0 0) nch w=1u l=1u

// p_1_0_0 = a10 * b00
I_P_1_0_0_A (vdd mem_p_1_0_0) isource type=pulse val0=0 val1=a10*iin_amp delay=10n rise=100p fall=100p width=2n period=200n
I_P_1_0_0_B (vdd mem_p_1_0_0) isource type=pulse val0=0 val1=b00*iin_amp delay=10n rise=100p fall=100p width=2n period=200n
C_P_1_0_0 (mem_p_1_0_0 0) capacitor c=cmul
R_P_1_0_0 (mem_p_1_0_0 0) resistor r=rmul
MP_P_1_0_0_1 (p_1_0_0_n mem_p_1_0_0 vdd vdd) pch_cmp w=2u l=1u
MN_P_1_0_0_1 (p_1_0_0_n mem_p_1_0_0 0 0) nch_cmp w=1u l=1u
MP_P_1_0_0_2 (p_1_0_0 p_1_0_0_n vdd vdd) pch w=2u l=1u
MN_P_1_0_0_2 (p_1_0_0 p_1_0_0_n 0 0) nch w=1u l=1u

// p_1_0_1 = a11 * b10
I_P_1_0_1_A (vdd mem_p_1_0_1) isource type=pulse val0=0 val1=a11*iin_amp delay=10n rise=100p fall=100p width=2n period=200n
I_P_1_0_1_B (vdd mem_p_1_0_1) isource type=pulse val0=0 val1=b10*iin_amp delay=10n rise=100p fall=100p width=2n period=200n
C_P_1_0_1 (mem_p_1_0_1 0) capacitor c=cmul
R_P_1_0_1 (mem_p_1_0_1 0) resistor r=rmul
MP_P_1_0_1_1 (p_1_0_1_n mem_p_1_0_1 vdd vdd) pch_cmp w=2u l=1u
MN_P_1_0_1_1 (p_1_0_1_n mem_p_1_0_1 0 0) nch_cmp w=1u l=1u
MP_P_1_0_1_2 (p_1_0_1 p_1_0_1_n vdd vdd) pch w=2u l=1u
MN_P_1_0_1_2 (p_1_0_1 p_1_0_1_n 0 0) nch w=1u l=1u

// p_1_0_2 = a12 * b20
I_P_1_0_2_A (vdd mem_p_1_0_2) isource type=pulse val0=0 val1=a12*iin_amp delay=10n rise=100p fall=100p width=2n period=200n
I_P_1_0_2_B (vdd mem_p_1_0_2) isource type=pulse val0=0 val1=b20*iin_amp delay=10n rise=100p fall=100p width=2n period=200n
C_P_1_0_2 (mem_p_1_0_2 0) capacitor c=cmul
R_P_1_0_2 (mem_p_1_0_2 0) resistor r=rmul
MP_P_1_0_2_1 (p_1_0_2_n mem_p_1_0_2 vdd vdd) pch_cmp w=2u l=1u
MN_P_1_0_2_1 (p_1_0_2_n mem_p_1_0_2 0 0) nch_cmp w=1u l=1u
MP_P_1_0_2_2 (p_1_0_2 p_1_0_2_n vdd vdd) pch w=2u l=1u
MN_P_1_0_2_2 (p_1_0_2 p_1_0_2_n 0 0) nch w=1u l=1u

// p_1_0_3 = a13 * b30
I_P_1_0_3_A (vdd mem_p_1_0_3) isource type=pulse val0=0 val1=a13*iin_amp delay=10n rise=100p fall=100p width=2n period=200n
I_P_1_0_3_B (vdd mem_p_1_0_3) isource type=pulse val0=0 val1=b30*iin_amp delay=10n rise=100p fall=100p width=2n period=200n
C_P_1_0_3 (mem_p_1_0_3 0) capacitor c=cmul
R_P_1_0_3 (mem_p_1_0_3 0) resistor r=rmul
MP_P_1_0_3_1 (p_1_0_3_n mem_p_1_0_3 vdd vdd) pch_cmp w=2u l=1u
MN_P_1_0_3_1 (p_1_0_3_n mem_p_1_0_3 0 0) nch_cmp w=1u l=1u
MP_P_1_0_3_2 (p_1_0_3 p_1_0_3_n vdd vdd) pch w=2u l=1u
MN_P_1_0_3_2 (p_1_0_3 p_1_0_3_n 0 0) nch w=1u l=1u

// p_1_1_0 = a10 * b01
I_P_1_1_0_A (vdd mem_p_1_1_0) isource type=pulse val0=0 val1=a10*iin_amp delay=10n rise=100p fall=100p width=2n period=200n
I_P_1_1_0_B (vdd mem_p_1_1_0) isource type=pulse val0=0 val1=b01*iin_amp delay=10n rise=100p fall=100p width=2n period=200n
C_P_1_1_0 (mem_p_1_1_0 0) capacitor c=cmul
R_P_1_1_0 (mem_p_1_1_0 0) resistor r=rmul
MP_P_1_1_0_1 (p_1_1_0_n mem_p_1_1_0 vdd vdd) pch_cmp w=2u l=1u
MN_P_1_1_0_1 (p_1_1_0_n mem_p_1_1_0 0 0) nch_cmp w=1u l=1u
MP_P_1_1_0_2 (p_1_1_0 p_1_1_0_n vdd vdd) pch w=2u l=1u
MN_P_1_1_0_2 (p_1_1_0 p_1_1_0_n 0 0) nch w=1u l=1u

// p_1_1_1 = a11 * b11
I_P_1_1_1_A (vdd mem_p_1_1_1) isource type=pulse val0=0 val1=a11*iin_amp delay=10n rise=100p fall=100p width=2n period=200n
I_P_1_1_1_B (vdd mem_p_1_1_1) isource type=pulse val0=0 val1=b11*iin_amp delay=10n rise=100p fall=100p width=2n period=200n
C_P_1_1_1 (mem_p_1_1_1 0) capacitor c=cmul
R_P_1_1_1 (mem_p_1_1_1 0) resistor r=rmul
MP_P_1_1_1_1 (p_1_1_1_n mem_p_1_1_1 vdd vdd) pch_cmp w=2u l=1u
MN_P_1_1_1_1 (p_1_1_1_n mem_p_1_1_1 0 0) nch_cmp w=1u l=1u
MP_P_1_1_1_2 (p_1_1_1 p_1_1_1_n vdd vdd) pch w=2u l=1u
MN_P_1_1_1_2 (p_1_1_1 p_1_1_1_n 0 0) nch w=1u l=1u

// p_1_1_2 = a12 * b21
I_P_1_1_2_A (vdd mem_p_1_1_2) isource type=pulse val0=0 val1=a12*iin_amp delay=10n rise=100p fall=100p width=2n period=200n
I_P_1_1_2_B (vdd mem_p_1_1_2) isource type=pulse val0=0 val1=b21*iin_amp delay=10n rise=100p fall=100p width=2n period=200n
C_P_1_1_2 (mem_p_1_1_2 0) capacitor c=cmul
R_P_1_1_2 (mem_p_1_1_2 0) resistor r=rmul
MP_P_1_1_2_1 (p_1_1_2_n mem_p_1_1_2 vdd vdd) pch_cmp w=2u l=1u
MN_P_1_1_2_1 (p_1_1_2_n mem_p_1_1_2 0 0) nch_cmp w=1u l=1u
MP_P_1_1_2_2 (p_1_1_2 p_1_1_2_n vdd vdd) pch w=2u l=1u
MN_P_1_1_2_2 (p_1_1_2 p_1_1_2_n 0 0) nch w=1u l=1u

// p_1_1_3 = a13 * b31
I_P_1_1_3_A (vdd mem_p_1_1_3) isource type=pulse val0=0 val1=a13*iin_amp delay=10n rise=100p fall=100p width=2n period=200n
I_P_1_1_3_B (vdd mem_p_1_1_3) isource type=pulse val0=0 val1=b31*iin_amp delay=10n rise=100p fall=100p width=2n period=200n
C_P_1_1_3 (mem_p_1_1_3 0) capacitor c=cmul
R_P_1_1_3 (mem_p_1_1_3 0) resistor r=rmul
MP_P_1_1_3_1 (p_1_1_3_n mem_p_1_1_3 vdd vdd) pch_cmp w=2u l=1u
MN_P_1_1_3_1 (p_1_1_3_n mem_p_1_1_3 0 0) nch_cmp w=1u l=1u
MP_P_1_1_3_2 (p_1_1_3 p_1_1_3_n vdd vdd) pch w=2u l=1u
MN_P_1_1_3_2 (p_1_1_3 p_1_1_3_n 0 0) nch w=1u l=1u

// p_1_2_0 = a10 * b02
I_P_1_2_0_A (vdd mem_p_1_2_0) isource type=pulse val0=0 val1=a10*iin_amp delay=10n rise=100p fall=100p width=2n period=200n
I_P_1_2_0_B (vdd mem_p_1_2_0) isource type=pulse val0=0 val1=b02*iin_amp delay=10n rise=100p fall=100p width=2n period=200n
C_P_1_2_0 (mem_p_1_2_0 0) capacitor c=cmul
R_P_1_2_0 (mem_p_1_2_0 0) resistor r=rmul
MP_P_1_2_0_1 (p_1_2_0_n mem_p_1_2_0 vdd vdd) pch_cmp w=2u l=1u
MN_P_1_2_0_1 (p_1_2_0_n mem_p_1_2_0 0 0) nch_cmp w=1u l=1u
MP_P_1_2_0_2 (p_1_2_0 p_1_2_0_n vdd vdd) pch w=2u l=1u
MN_P_1_2_0_2 (p_1_2_0 p_1_2_0_n 0 0) nch w=1u l=1u

// p_1_2_1 = a11 * b12
I_P_1_2_1_A (vdd mem_p_1_2_1) isource type=pulse val0=0 val1=a11*iin_amp delay=10n rise=100p fall=100p width=2n period=200n
I_P_1_2_1_B (vdd mem_p_1_2_1) isource type=pulse val0=0 val1=b12*iin_amp delay=10n rise=100p fall=100p width=2n period=200n
C_P_1_2_1 (mem_p_1_2_1 0) capacitor c=cmul
R_P_1_2_1 (mem_p_1_2_1 0) resistor r=rmul
MP_P_1_2_1_1 (p_1_2_1_n mem_p_1_2_1 vdd vdd) pch_cmp w=2u l=1u
MN_P_1_2_1_1 (p_1_2_1_n mem_p_1_2_1 0 0) nch_cmp w=1u l=1u
MP_P_1_2_1_2 (p_1_2_1 p_1_2_1_n vdd vdd) pch w=2u l=1u
MN_P_1_2_1_2 (p_1_2_1 p_1_2_1_n 0 0) nch w=1u l=1u

// p_1_2_2 = a12 * b22
I_P_1_2_2_A (vdd mem_p_1_2_2) isource type=pulse val0=0 val1=a12*iin_amp delay=10n rise=100p fall=100p width=2n period=200n
I_P_1_2_2_B (vdd mem_p_1_2_2) isource type=pulse val0=0 val1=b22*iin_amp delay=10n rise=100p fall=100p width=2n period=200n
C_P_1_2_2 (mem_p_1_2_2 0) capacitor c=cmul
R_P_1_2_2 (mem_p_1_2_2 0) resistor r=rmul
MP_P_1_2_2_1 (p_1_2_2_n mem_p_1_2_2 vdd vdd) pch_cmp w=2u l=1u
MN_P_1_2_2_1 (p_1_2_2_n mem_p_1_2_2 0 0) nch_cmp w=1u l=1u
MP_P_1_2_2_2 (p_1_2_2 p_1_2_2_n vdd vdd) pch w=2u l=1u
MN_P_1_2_2_2 (p_1_2_2 p_1_2_2_n 0 0) nch w=1u l=1u

// p_1_2_3 = a13 * b32
I_P_1_2_3_A (vdd mem_p_1_2_3) isource type=pulse val0=0 val1=a13*iin_amp delay=10n rise=100p fall=100p width=2n period=200n
I_P_1_2_3_B (vdd mem_p_1_2_3) isource type=pulse val0=0 val1=b32*iin_amp delay=10n rise=100p fall=100p width=2n period=200n
C_P_1_2_3 (mem_p_1_2_3 0) capacitor c=cmul
R_P_1_2_3 (mem_p_1_2_3 0) resistor r=rmul
MP_P_1_2_3_1 (p_1_2_3_n mem_p_1_2_3 vdd vdd) pch_cmp w=2u l=1u
MN_P_1_2_3_1 (p_1_2_3_n mem_p_1_2_3 0 0) nch_cmp w=1u l=1u
MP_P_1_2_3_2 (p_1_2_3 p_1_2_3_n vdd vdd) pch w=2u l=1u
MN_P_1_2_3_2 (p_1_2_3 p_1_2_3_n 0 0) nch w=1u l=1u

// p_1_3_0 = a10 * b03
I_P_1_3_0_A (vdd mem_p_1_3_0) isource type=pulse val0=0 val1=a10*iin_amp delay=10n rise=100p fall=100p width=2n period=200n
I_P_1_3_0_B (vdd mem_p_1_3_0) isource type=pulse val0=0 val1=b03*iin_amp delay=10n rise=100p fall=100p width=2n period=200n
C_P_1_3_0 (mem_p_1_3_0 0) capacitor c=cmul
R_P_1_3_0 (mem_p_1_3_0 0) resistor r=rmul
MP_P_1_3_0_1 (p_1_3_0_n mem_p_1_3_0 vdd vdd) pch_cmp w=2u l=1u
MN_P_1_3_0_1 (p_1_3_0_n mem_p_1_3_0 0 0) nch_cmp w=1u l=1u
MP_P_1_3_0_2 (p_1_3_0 p_1_3_0_n vdd vdd) pch w=2u l=1u
MN_P_1_3_0_2 (p_1_3_0 p_1_3_0_n 0 0) nch w=1u l=1u

// p_1_3_1 = a11 * b13
I_P_1_3_1_A (vdd mem_p_1_3_1) isource type=pulse val0=0 val1=a11*iin_amp delay=10n rise=100p fall=100p width=2n period=200n
I_P_1_3_1_B (vdd mem_p_1_3_1) isource type=pulse val0=0 val1=b13*iin_amp delay=10n rise=100p fall=100p width=2n period=200n
C_P_1_3_1 (mem_p_1_3_1 0) capacitor c=cmul
R_P_1_3_1 (mem_p_1_3_1 0) resistor r=rmul
MP_P_1_3_1_1 (p_1_3_1_n mem_p_1_3_1 vdd vdd) pch_cmp w=2u l=1u
MN_P_1_3_1_1 (p_1_3_1_n mem_p_1_3_1 0 0) nch_cmp w=1u l=1u
MP_P_1_3_1_2 (p_1_3_1 p_1_3_1_n vdd vdd) pch w=2u l=1u
MN_P_1_3_1_2 (p_1_3_1 p_1_3_1_n 0 0) nch w=1u l=1u

// p_1_3_2 = a12 * b23
I_P_1_3_2_A (vdd mem_p_1_3_2) isource type=pulse val0=0 val1=a12*iin_amp delay=10n rise=100p fall=100p width=2n period=200n
I_P_1_3_2_B (vdd mem_p_1_3_2) isource type=pulse val0=0 val1=b23*iin_amp delay=10n rise=100p fall=100p width=2n period=200n
C_P_1_3_2 (mem_p_1_3_2 0) capacitor c=cmul
R_P_1_3_2 (mem_p_1_3_2 0) resistor r=rmul
MP_P_1_3_2_1 (p_1_3_2_n mem_p_1_3_2 vdd vdd) pch_cmp w=2u l=1u
MN_P_1_3_2_1 (p_1_3_2_n mem_p_1_3_2 0 0) nch_cmp w=1u l=1u
MP_P_1_3_2_2 (p_1_3_2 p_1_3_2_n vdd vdd) pch w=2u l=1u
MN_P_1_3_2_2 (p_1_3_2 p_1_3_2_n 0 0) nch w=1u l=1u

// p_1_3_3 = a13 * b33
I_P_1_3_3_A (vdd mem_p_1_3_3) isource type=pulse val0=0 val1=a13*iin_amp delay=10n rise=100p fall=100p width=2n period=200n
I_P_1_3_3_B (vdd mem_p_1_3_3) isource type=pulse val0=0 val1=b33*iin_amp delay=10n rise=100p fall=100p width=2n period=200n
C_P_1_3_3 (mem_p_1_3_3 0) capacitor c=cmul
R_P_1_3_3 (mem_p_1_3_3 0) resistor r=rmul
MP_P_1_3_3_1 (p_1_3_3_n mem_p_1_3_3 vdd vdd) pch_cmp w=2u l=1u
MN_P_1_3_3_1 (p_1_3_3_n mem_p_1_3_3 0 0) nch_cmp w=1u l=1u
MP_P_1_3_3_2 (p_1_3_3 p_1_3_3_n vdd vdd) pch w=2u l=1u
MN_P_1_3_3_2 (p_1_3_3 p_1_3_3_n 0 0) nch w=1u l=1u

// p_2_0_0 = a20 * b00
I_P_2_0_0_A (vdd mem_p_2_0_0) isource type=pulse val0=0 val1=a20*iin_amp delay=10n rise=100p fall=100p width=2n period=200n
I_P_2_0_0_B (vdd mem_p_2_0_0) isource type=pulse val0=0 val1=b00*iin_amp delay=10n rise=100p fall=100p width=2n period=200n
C_P_2_0_0 (mem_p_2_0_0 0) capacitor c=cmul
R_P_2_0_0 (mem_p_2_0_0 0) resistor r=rmul
MP_P_2_0_0_1 (p_2_0_0_n mem_p_2_0_0 vdd vdd) pch_cmp w=2u l=1u
MN_P_2_0_0_1 (p_2_0_0_n mem_p_2_0_0 0 0) nch_cmp w=1u l=1u
MP_P_2_0_0_2 (p_2_0_0 p_2_0_0_n vdd vdd) pch w=2u l=1u
MN_P_2_0_0_2 (p_2_0_0 p_2_0_0_n 0 0) nch w=1u l=1u

// p_2_0_1 = a21 * b10
I_P_2_0_1_A (vdd mem_p_2_0_1) isource type=pulse val0=0 val1=a21*iin_amp delay=10n rise=100p fall=100p width=2n period=200n
I_P_2_0_1_B (vdd mem_p_2_0_1) isource type=pulse val0=0 val1=b10*iin_amp delay=10n rise=100p fall=100p width=2n period=200n
C_P_2_0_1 (mem_p_2_0_1 0) capacitor c=cmul
R_P_2_0_1 (mem_p_2_0_1 0) resistor r=rmul
MP_P_2_0_1_1 (p_2_0_1_n mem_p_2_0_1 vdd vdd) pch_cmp w=2u l=1u
MN_P_2_0_1_1 (p_2_0_1_n mem_p_2_0_1 0 0) nch_cmp w=1u l=1u
MP_P_2_0_1_2 (p_2_0_1 p_2_0_1_n vdd vdd) pch w=2u l=1u
MN_P_2_0_1_2 (p_2_0_1 p_2_0_1_n 0 0) nch w=1u l=1u

// p_2_0_2 = a22 * b20
I_P_2_0_2_A (vdd mem_p_2_0_2) isource type=pulse val0=0 val1=a22*iin_amp delay=10n rise=100p fall=100p width=2n period=200n
I_P_2_0_2_B (vdd mem_p_2_0_2) isource type=pulse val0=0 val1=b20*iin_amp delay=10n rise=100p fall=100p width=2n period=200n
C_P_2_0_2 (mem_p_2_0_2 0) capacitor c=cmul
R_P_2_0_2 (mem_p_2_0_2 0) resistor r=rmul
MP_P_2_0_2_1 (p_2_0_2_n mem_p_2_0_2 vdd vdd) pch_cmp w=2u l=1u
MN_P_2_0_2_1 (p_2_0_2_n mem_p_2_0_2 0 0) nch_cmp w=1u l=1u
MP_P_2_0_2_2 (p_2_0_2 p_2_0_2_n vdd vdd) pch w=2u l=1u
MN_P_2_0_2_2 (p_2_0_2 p_2_0_2_n 0 0) nch w=1u l=1u

// p_2_0_3 = a23 * b30
I_P_2_0_3_A (vdd mem_p_2_0_3) isource type=pulse val0=0 val1=a23*iin_amp delay=10n rise=100p fall=100p width=2n period=200n
I_P_2_0_3_B (vdd mem_p_2_0_3) isource type=pulse val0=0 val1=b30*iin_amp delay=10n rise=100p fall=100p width=2n period=200n
C_P_2_0_3 (mem_p_2_0_3 0) capacitor c=cmul
R_P_2_0_3 (mem_p_2_0_3 0) resistor r=rmul
MP_P_2_0_3_1 (p_2_0_3_n mem_p_2_0_3 vdd vdd) pch_cmp w=2u l=1u
MN_P_2_0_3_1 (p_2_0_3_n mem_p_2_0_3 0 0) nch_cmp w=1u l=1u
MP_P_2_0_3_2 (p_2_0_3 p_2_0_3_n vdd vdd) pch w=2u l=1u
MN_P_2_0_3_2 (p_2_0_3 p_2_0_3_n 0 0) nch w=1u l=1u

// p_2_1_0 = a20 * b01
I_P_2_1_0_A (vdd mem_p_2_1_0) isource type=pulse val0=0 val1=a20*iin_amp delay=10n rise=100p fall=100p width=2n period=200n
I_P_2_1_0_B (vdd mem_p_2_1_0) isource type=pulse val0=0 val1=b01*iin_amp delay=10n rise=100p fall=100p width=2n period=200n
C_P_2_1_0 (mem_p_2_1_0 0) capacitor c=cmul
R_P_2_1_0 (mem_p_2_1_0 0) resistor r=rmul
MP_P_2_1_0_1 (p_2_1_0_n mem_p_2_1_0 vdd vdd) pch_cmp w=2u l=1u
MN_P_2_1_0_1 (p_2_1_0_n mem_p_2_1_0 0 0) nch_cmp w=1u l=1u
MP_P_2_1_0_2 (p_2_1_0 p_2_1_0_n vdd vdd) pch w=2u l=1u
MN_P_2_1_0_2 (p_2_1_0 p_2_1_0_n 0 0) nch w=1u l=1u

// p_2_1_1 = a21 * b11
I_P_2_1_1_A (vdd mem_p_2_1_1) isource type=pulse val0=0 val1=a21*iin_amp delay=10n rise=100p fall=100p width=2n period=200n
I_P_2_1_1_B (vdd mem_p_2_1_1) isource type=pulse val0=0 val1=b11*iin_amp delay=10n rise=100p fall=100p width=2n period=200n
C_P_2_1_1 (mem_p_2_1_1 0) capacitor c=cmul
R_P_2_1_1 (mem_p_2_1_1 0) resistor r=rmul
MP_P_2_1_1_1 (p_2_1_1_n mem_p_2_1_1 vdd vdd) pch_cmp w=2u l=1u
MN_P_2_1_1_1 (p_2_1_1_n mem_p_2_1_1 0 0) nch_cmp w=1u l=1u
MP_P_2_1_1_2 (p_2_1_1 p_2_1_1_n vdd vdd) pch w=2u l=1u
MN_P_2_1_1_2 (p_2_1_1 p_2_1_1_n 0 0) nch w=1u l=1u

// p_2_1_2 = a22 * b21
I_P_2_1_2_A (vdd mem_p_2_1_2) isource type=pulse val0=0 val1=a22*iin_amp delay=10n rise=100p fall=100p width=2n period=200n
I_P_2_1_2_B (vdd mem_p_2_1_2) isource type=pulse val0=0 val1=b21*iin_amp delay=10n rise=100p fall=100p width=2n period=200n
C_P_2_1_2 (mem_p_2_1_2 0) capacitor c=cmul
R_P_2_1_2 (mem_p_2_1_2 0) resistor r=rmul
MP_P_2_1_2_1 (p_2_1_2_n mem_p_2_1_2 vdd vdd) pch_cmp w=2u l=1u
MN_P_2_1_2_1 (p_2_1_2_n mem_p_2_1_2 0 0) nch_cmp w=1u l=1u
MP_P_2_1_2_2 (p_2_1_2 p_2_1_2_n vdd vdd) pch w=2u l=1u
MN_P_2_1_2_2 (p_2_1_2 p_2_1_2_n 0 0) nch w=1u l=1u

// p_2_1_3 = a23 * b31
I_P_2_1_3_A (vdd mem_p_2_1_3) isource type=pulse val0=0 val1=a23*iin_amp delay=10n rise=100p fall=100p width=2n period=200n
I_P_2_1_3_B (vdd mem_p_2_1_3) isource type=pulse val0=0 val1=b31*iin_amp delay=10n rise=100p fall=100p width=2n period=200n
C_P_2_1_3 (mem_p_2_1_3 0) capacitor c=cmul
R_P_2_1_3 (mem_p_2_1_3 0) resistor r=rmul
MP_P_2_1_3_1 (p_2_1_3_n mem_p_2_1_3 vdd vdd) pch_cmp w=2u l=1u
MN_P_2_1_3_1 (p_2_1_3_n mem_p_2_1_3 0 0) nch_cmp w=1u l=1u
MP_P_2_1_3_2 (p_2_1_3 p_2_1_3_n vdd vdd) pch w=2u l=1u
MN_P_2_1_3_2 (p_2_1_3 p_2_1_3_n 0 0) nch w=1u l=1u

// p_2_2_0 = a20 * b02
I_P_2_2_0_A (vdd mem_p_2_2_0) isource type=pulse val0=0 val1=a20*iin_amp delay=10n rise=100p fall=100p width=2n period=200n
I_P_2_2_0_B (vdd mem_p_2_2_0) isource type=pulse val0=0 val1=b02*iin_amp delay=10n rise=100p fall=100p width=2n period=200n
C_P_2_2_0 (mem_p_2_2_0 0) capacitor c=cmul
R_P_2_2_0 (mem_p_2_2_0 0) resistor r=rmul
MP_P_2_2_0_1 (p_2_2_0_n mem_p_2_2_0 vdd vdd) pch_cmp w=2u l=1u
MN_P_2_2_0_1 (p_2_2_0_n mem_p_2_2_0 0 0) nch_cmp w=1u l=1u
MP_P_2_2_0_2 (p_2_2_0 p_2_2_0_n vdd vdd) pch w=2u l=1u
MN_P_2_2_0_2 (p_2_2_0 p_2_2_0_n 0 0) nch w=1u l=1u

// p_2_2_1 = a21 * b12
I_P_2_2_1_A (vdd mem_p_2_2_1) isource type=pulse val0=0 val1=a21*iin_amp delay=10n rise=100p fall=100p width=2n period=200n
I_P_2_2_1_B (vdd mem_p_2_2_1) isource type=pulse val0=0 val1=b12*iin_amp delay=10n rise=100p fall=100p width=2n period=200n
C_P_2_2_1 (mem_p_2_2_1 0) capacitor c=cmul
R_P_2_2_1 (mem_p_2_2_1 0) resistor r=rmul
MP_P_2_2_1_1 (p_2_2_1_n mem_p_2_2_1 vdd vdd) pch_cmp w=2u l=1u
MN_P_2_2_1_1 (p_2_2_1_n mem_p_2_2_1 0 0) nch_cmp w=1u l=1u
MP_P_2_2_1_2 (p_2_2_1 p_2_2_1_n vdd vdd) pch w=2u l=1u
MN_P_2_2_1_2 (p_2_2_1 p_2_2_1_n 0 0) nch w=1u l=1u

// p_2_2_2 = a22 * b22
I_P_2_2_2_A (vdd mem_p_2_2_2) isource type=pulse val0=0 val1=a22*iin_amp delay=10n rise=100p fall=100p width=2n period=200n
I_P_2_2_2_B (vdd mem_p_2_2_2) isource type=pulse val0=0 val1=b22*iin_amp delay=10n rise=100p fall=100p width=2n period=200n
C_P_2_2_2 (mem_p_2_2_2 0) capacitor c=cmul
R_P_2_2_2 (mem_p_2_2_2 0) resistor r=rmul
MP_P_2_2_2_1 (p_2_2_2_n mem_p_2_2_2 vdd vdd) pch_cmp w=2u l=1u
MN_P_2_2_2_1 (p_2_2_2_n mem_p_2_2_2 0 0) nch_cmp w=1u l=1u
MP_P_2_2_2_2 (p_2_2_2 p_2_2_2_n vdd vdd) pch w=2u l=1u
MN_P_2_2_2_2 (p_2_2_2 p_2_2_2_n 0 0) nch w=1u l=1u

// p_2_2_3 = a23 * b32
I_P_2_2_3_A (vdd mem_p_2_2_3) isource type=pulse val0=0 val1=a23*iin_amp delay=10n rise=100p fall=100p width=2n period=200n
I_P_2_2_3_B (vdd mem_p_2_2_3) isource type=pulse val0=0 val1=b32*iin_amp delay=10n rise=100p fall=100p width=2n period=200n
C_P_2_2_3 (mem_p_2_2_3 0) capacitor c=cmul
R_P_2_2_3 (mem_p_2_2_3 0) resistor r=rmul
MP_P_2_2_3_1 (p_2_2_3_n mem_p_2_2_3 vdd vdd) pch_cmp w=2u l=1u
MN_P_2_2_3_1 (p_2_2_3_n mem_p_2_2_3 0 0) nch_cmp w=1u l=1u
MP_P_2_2_3_2 (p_2_2_3 p_2_2_3_n vdd vdd) pch w=2u l=1u
MN_P_2_2_3_2 (p_2_2_3 p_2_2_3_n 0 0) nch w=1u l=1u

// p_2_3_0 = a20 * b03
I_P_2_3_0_A (vdd mem_p_2_3_0) isource type=pulse val0=0 val1=a20*iin_amp delay=10n rise=100p fall=100p width=2n period=200n
I_P_2_3_0_B (vdd mem_p_2_3_0) isource type=pulse val0=0 val1=b03*iin_amp delay=10n rise=100p fall=100p width=2n period=200n
C_P_2_3_0 (mem_p_2_3_0 0) capacitor c=cmul
R_P_2_3_0 (mem_p_2_3_0 0) resistor r=rmul
MP_P_2_3_0_1 (p_2_3_0_n mem_p_2_3_0 vdd vdd) pch_cmp w=2u l=1u
MN_P_2_3_0_1 (p_2_3_0_n mem_p_2_3_0 0 0) nch_cmp w=1u l=1u
MP_P_2_3_0_2 (p_2_3_0 p_2_3_0_n vdd vdd) pch w=2u l=1u
MN_P_2_3_0_2 (p_2_3_0 p_2_3_0_n 0 0) nch w=1u l=1u

// p_2_3_1 = a21 * b13
I_P_2_3_1_A (vdd mem_p_2_3_1) isource type=pulse val0=0 val1=a21*iin_amp delay=10n rise=100p fall=100p width=2n period=200n
I_P_2_3_1_B (vdd mem_p_2_3_1) isource type=pulse val0=0 val1=b13*iin_amp delay=10n rise=100p fall=100p width=2n period=200n
C_P_2_3_1 (mem_p_2_3_1 0) capacitor c=cmul
R_P_2_3_1 (mem_p_2_3_1 0) resistor r=rmul
MP_P_2_3_1_1 (p_2_3_1_n mem_p_2_3_1 vdd vdd) pch_cmp w=2u l=1u
MN_P_2_3_1_1 (p_2_3_1_n mem_p_2_3_1 0 0) nch_cmp w=1u l=1u
MP_P_2_3_1_2 (p_2_3_1 p_2_3_1_n vdd vdd) pch w=2u l=1u
MN_P_2_3_1_2 (p_2_3_1 p_2_3_1_n 0 0) nch w=1u l=1u

// p_2_3_2 = a22 * b23
I_P_2_3_2_A (vdd mem_p_2_3_2) isource type=pulse val0=0 val1=a22*iin_amp delay=10n rise=100p fall=100p width=2n period=200n
I_P_2_3_2_B (vdd mem_p_2_3_2) isource type=pulse val0=0 val1=b23*iin_amp delay=10n rise=100p fall=100p width=2n period=200n
C_P_2_3_2 (mem_p_2_3_2 0) capacitor c=cmul
R_P_2_3_2 (mem_p_2_3_2 0) resistor r=rmul
MP_P_2_3_2_1 (p_2_3_2_n mem_p_2_3_2 vdd vdd) pch_cmp w=2u l=1u
MN_P_2_3_2_1 (p_2_3_2_n mem_p_2_3_2 0 0) nch_cmp w=1u l=1u
MP_P_2_3_2_2 (p_2_3_2 p_2_3_2_n vdd vdd) pch w=2u l=1u
MN_P_2_3_2_2 (p_2_3_2 p_2_3_2_n 0 0) nch w=1u l=1u

// p_2_3_3 = a23 * b33
I_P_2_3_3_A (vdd mem_p_2_3_3) isource type=pulse val0=0 val1=a23*iin_amp delay=10n rise=100p fall=100p width=2n period=200n
I_P_2_3_3_B (vdd mem_p_2_3_3) isource type=pulse val0=0 val1=b33*iin_amp delay=10n rise=100p fall=100p width=2n period=200n
C_P_2_3_3 (mem_p_2_3_3 0) capacitor c=cmul
R_P_2_3_3 (mem_p_2_3_3 0) resistor r=rmul
MP_P_2_3_3_1 (p_2_3_3_n mem_p_2_3_3 vdd vdd) pch_cmp w=2u l=1u
MN_P_2_3_3_1 (p_2_3_3_n mem_p_2_3_3 0 0) nch_cmp w=1u l=1u
MP_P_2_3_3_2 (p_2_3_3 p_2_3_3_n vdd vdd) pch w=2u l=1u
MN_P_2_3_3_2 (p_2_3_3 p_2_3_3_n 0 0) nch w=1u l=1u

// p_3_0_0 = a30 * b00
I_P_3_0_0_A (vdd mem_p_3_0_0) isource type=pulse val0=0 val1=a30*iin_amp delay=10n rise=100p fall=100p width=2n period=200n
I_P_3_0_0_B (vdd mem_p_3_0_0) isource type=pulse val0=0 val1=b00*iin_amp delay=10n rise=100p fall=100p width=2n period=200n
C_P_3_0_0 (mem_p_3_0_0 0) capacitor c=cmul
R_P_3_0_0 (mem_p_3_0_0 0) resistor r=rmul
MP_P_3_0_0_1 (p_3_0_0_n mem_p_3_0_0 vdd vdd) pch_cmp w=2u l=1u
MN_P_3_0_0_1 (p_3_0_0_n mem_p_3_0_0 0 0) nch_cmp w=1u l=1u
MP_P_3_0_0_2 (p_3_0_0 p_3_0_0_n vdd vdd) pch w=2u l=1u
MN_P_3_0_0_2 (p_3_0_0 p_3_0_0_n 0 0) nch w=1u l=1u

// p_3_0_1 = a31 * b10
I_P_3_0_1_A (vdd mem_p_3_0_1) isource type=pulse val0=0 val1=a31*iin_amp delay=10n rise=100p fall=100p width=2n period=200n
I_P_3_0_1_B (vdd mem_p_3_0_1) isource type=pulse val0=0 val1=b10*iin_amp delay=10n rise=100p fall=100p width=2n period=200n
C_P_3_0_1 (mem_p_3_0_1 0) capacitor c=cmul
R_P_3_0_1 (mem_p_3_0_1 0) resistor r=rmul
MP_P_3_0_1_1 (p_3_0_1_n mem_p_3_0_1 vdd vdd) pch_cmp w=2u l=1u
MN_P_3_0_1_1 (p_3_0_1_n mem_p_3_0_1 0 0) nch_cmp w=1u l=1u
MP_P_3_0_1_2 (p_3_0_1 p_3_0_1_n vdd vdd) pch w=2u l=1u
MN_P_3_0_1_2 (p_3_0_1 p_3_0_1_n 0 0) nch w=1u l=1u

// p_3_0_2 = a32 * b20
I_P_3_0_2_A (vdd mem_p_3_0_2) isource type=pulse val0=0 val1=a32*iin_amp delay=10n rise=100p fall=100p width=2n period=200n
I_P_3_0_2_B (vdd mem_p_3_0_2) isource type=pulse val0=0 val1=b20*iin_amp delay=10n rise=100p fall=100p width=2n period=200n
C_P_3_0_2 (mem_p_3_0_2 0) capacitor c=cmul
R_P_3_0_2 (mem_p_3_0_2 0) resistor r=rmul
MP_P_3_0_2_1 (p_3_0_2_n mem_p_3_0_2 vdd vdd) pch_cmp w=2u l=1u
MN_P_3_0_2_1 (p_3_0_2_n mem_p_3_0_2 0 0) nch_cmp w=1u l=1u
MP_P_3_0_2_2 (p_3_0_2 p_3_0_2_n vdd vdd) pch w=2u l=1u
MN_P_3_0_2_2 (p_3_0_2 p_3_0_2_n 0 0) nch w=1u l=1u

// p_3_0_3 = a33 * b30
I_P_3_0_3_A (vdd mem_p_3_0_3) isource type=pulse val0=0 val1=a33*iin_amp delay=10n rise=100p fall=100p width=2n period=200n
I_P_3_0_3_B (vdd mem_p_3_0_3) isource type=pulse val0=0 val1=b30*iin_amp delay=10n rise=100p fall=100p width=2n period=200n
C_P_3_0_3 (mem_p_3_0_3 0) capacitor c=cmul
R_P_3_0_3 (mem_p_3_0_3 0) resistor r=rmul
MP_P_3_0_3_1 (p_3_0_3_n mem_p_3_0_3 vdd vdd) pch_cmp w=2u l=1u
MN_P_3_0_3_1 (p_3_0_3_n mem_p_3_0_3 0 0) nch_cmp w=1u l=1u
MP_P_3_0_3_2 (p_3_0_3 p_3_0_3_n vdd vdd) pch w=2u l=1u
MN_P_3_0_3_2 (p_3_0_3 p_3_0_3_n 0 0) nch w=1u l=1u

// p_3_1_0 = a30 * b01
I_P_3_1_0_A (vdd mem_p_3_1_0) isource type=pulse val0=0 val1=a30*iin_amp delay=10n rise=100p fall=100p width=2n period=200n
I_P_3_1_0_B (vdd mem_p_3_1_0) isource type=pulse val0=0 val1=b01*iin_amp delay=10n rise=100p fall=100p width=2n period=200n
C_P_3_1_0 (mem_p_3_1_0 0) capacitor c=cmul
R_P_3_1_0 (mem_p_3_1_0 0) resistor r=rmul
MP_P_3_1_0_1 (p_3_1_0_n mem_p_3_1_0 vdd vdd) pch_cmp w=2u l=1u
MN_P_3_1_0_1 (p_3_1_0_n mem_p_3_1_0 0 0) nch_cmp w=1u l=1u
MP_P_3_1_0_2 (p_3_1_0 p_3_1_0_n vdd vdd) pch w=2u l=1u
MN_P_3_1_0_2 (p_3_1_0 p_3_1_0_n 0 0) nch w=1u l=1u

// p_3_1_1 = a31 * b11
I_P_3_1_1_A (vdd mem_p_3_1_1) isource type=pulse val0=0 val1=a31*iin_amp delay=10n rise=100p fall=100p width=2n period=200n
I_P_3_1_1_B (vdd mem_p_3_1_1) isource type=pulse val0=0 val1=b11*iin_amp delay=10n rise=100p fall=100p width=2n period=200n
C_P_3_1_1 (mem_p_3_1_1 0) capacitor c=cmul
R_P_3_1_1 (mem_p_3_1_1 0) resistor r=rmul
MP_P_3_1_1_1 (p_3_1_1_n mem_p_3_1_1 vdd vdd) pch_cmp w=2u l=1u
MN_P_3_1_1_1 (p_3_1_1_n mem_p_3_1_1 0 0) nch_cmp w=1u l=1u
MP_P_3_1_1_2 (p_3_1_1 p_3_1_1_n vdd vdd) pch w=2u l=1u
MN_P_3_1_1_2 (p_3_1_1 p_3_1_1_n 0 0) nch w=1u l=1u

// p_3_1_2 = a32 * b21
I_P_3_1_2_A (vdd mem_p_3_1_2) isource type=pulse val0=0 val1=a32*iin_amp delay=10n rise=100p fall=100p width=2n period=200n
I_P_3_1_2_B (vdd mem_p_3_1_2) isource type=pulse val0=0 val1=b21*iin_amp delay=10n rise=100p fall=100p width=2n period=200n
C_P_3_1_2 (mem_p_3_1_2 0) capacitor c=cmul
R_P_3_1_2 (mem_p_3_1_2 0) resistor r=rmul
MP_P_3_1_2_1 (p_3_1_2_n mem_p_3_1_2 vdd vdd) pch_cmp w=2u l=1u
MN_P_3_1_2_1 (p_3_1_2_n mem_p_3_1_2 0 0) nch_cmp w=1u l=1u
MP_P_3_1_2_2 (p_3_1_2 p_3_1_2_n vdd vdd) pch w=2u l=1u
MN_P_3_1_2_2 (p_3_1_2 p_3_1_2_n 0 0) nch w=1u l=1u

// p_3_1_3 = a33 * b31
I_P_3_1_3_A (vdd mem_p_3_1_3) isource type=pulse val0=0 val1=a33*iin_amp delay=10n rise=100p fall=100p width=2n period=200n
I_P_3_1_3_B (vdd mem_p_3_1_3) isource type=pulse val0=0 val1=b31*iin_amp delay=10n rise=100p fall=100p width=2n period=200n
C_P_3_1_3 (mem_p_3_1_3 0) capacitor c=cmul
R_P_3_1_3 (mem_p_3_1_3 0) resistor r=rmul
MP_P_3_1_3_1 (p_3_1_3_n mem_p_3_1_3 vdd vdd) pch_cmp w=2u l=1u
MN_P_3_1_3_1 (p_3_1_3_n mem_p_3_1_3 0 0) nch_cmp w=1u l=1u
MP_P_3_1_3_2 (p_3_1_3 p_3_1_3_n vdd vdd) pch w=2u l=1u
MN_P_3_1_3_2 (p_3_1_3 p_3_1_3_n 0 0) nch w=1u l=1u

// p_3_2_0 = a30 * b02
I_P_3_2_0_A (vdd mem_p_3_2_0) isource type=pulse val0=0 val1=a30*iin_amp delay=10n rise=100p fall=100p width=2n period=200n
I_P_3_2_0_B (vdd mem_p_3_2_0) isource type=pulse val0=0 val1=b02*iin_amp delay=10n rise=100p fall=100p width=2n period=200n
C_P_3_2_0 (mem_p_3_2_0 0) capacitor c=cmul
R_P_3_2_0 (mem_p_3_2_0 0) resistor r=rmul
MP_P_3_2_0_1 (p_3_2_0_n mem_p_3_2_0 vdd vdd) pch_cmp w=2u l=1u
MN_P_3_2_0_1 (p_3_2_0_n mem_p_3_2_0 0 0) nch_cmp w=1u l=1u
MP_P_3_2_0_2 (p_3_2_0 p_3_2_0_n vdd vdd) pch w=2u l=1u
MN_P_3_2_0_2 (p_3_2_0 p_3_2_0_n 0 0) nch w=1u l=1u

// p_3_2_1 = a31 * b12
I_P_3_2_1_A (vdd mem_p_3_2_1) isource type=pulse val0=0 val1=a31*iin_amp delay=10n rise=100p fall=100p width=2n period=200n
I_P_3_2_1_B (vdd mem_p_3_2_1) isource type=pulse val0=0 val1=b12*iin_amp delay=10n rise=100p fall=100p width=2n period=200n
C_P_3_2_1 (mem_p_3_2_1 0) capacitor c=cmul
R_P_3_2_1 (mem_p_3_2_1 0) resistor r=rmul
MP_P_3_2_1_1 (p_3_2_1_n mem_p_3_2_1 vdd vdd) pch_cmp w=2u l=1u
MN_P_3_2_1_1 (p_3_2_1_n mem_p_3_2_1 0 0) nch_cmp w=1u l=1u
MP_P_3_2_1_2 (p_3_2_1 p_3_2_1_n vdd vdd) pch w=2u l=1u
MN_P_3_2_1_2 (p_3_2_1 p_3_2_1_n 0 0) nch w=1u l=1u

// p_3_2_2 = a32 * b22
I_P_3_2_2_A (vdd mem_p_3_2_2) isource type=pulse val0=0 val1=a32*iin_amp delay=10n rise=100p fall=100p width=2n period=200n
I_P_3_2_2_B (vdd mem_p_3_2_2) isource type=pulse val0=0 val1=b22*iin_amp delay=10n rise=100p fall=100p width=2n period=200n
C_P_3_2_2 (mem_p_3_2_2 0) capacitor c=cmul
R_P_3_2_2 (mem_p_3_2_2 0) resistor r=rmul
MP_P_3_2_2_1 (p_3_2_2_n mem_p_3_2_2 vdd vdd) pch_cmp w=2u l=1u
MN_P_3_2_2_1 (p_3_2_2_n mem_p_3_2_2 0 0) nch_cmp w=1u l=1u
MP_P_3_2_2_2 (p_3_2_2 p_3_2_2_n vdd vdd) pch w=2u l=1u
MN_P_3_2_2_2 (p_3_2_2 p_3_2_2_n 0 0) nch w=1u l=1u

// p_3_2_3 = a33 * b32
I_P_3_2_3_A (vdd mem_p_3_2_3) isource type=pulse val0=0 val1=a33*iin_amp delay=10n rise=100p fall=100p width=2n period=200n
I_P_3_2_3_B (vdd mem_p_3_2_3) isource type=pulse val0=0 val1=b32*iin_amp delay=10n rise=100p fall=100p width=2n period=200n
C_P_3_2_3 (mem_p_3_2_3 0) capacitor c=cmul
R_P_3_2_3 (mem_p_3_2_3 0) resistor r=rmul
MP_P_3_2_3_1 (p_3_2_3_n mem_p_3_2_3 vdd vdd) pch_cmp w=2u l=1u
MN_P_3_2_3_1 (p_3_2_3_n mem_p_3_2_3 0 0) nch_cmp w=1u l=1u
MP_P_3_2_3_2 (p_3_2_3 p_3_2_3_n vdd vdd) pch w=2u l=1u
MN_P_3_2_3_2 (p_3_2_3 p_3_2_3_n 0 0) nch w=1u l=1u

// p_3_3_0 = a30 * b03
I_P_3_3_0_A (vdd mem_p_3_3_0) isource type=pulse val0=0 val1=a30*iin_amp delay=10n rise=100p fall=100p width=2n period=200n
I_P_3_3_0_B (vdd mem_p_3_3_0) isource type=pulse val0=0 val1=b03*iin_amp delay=10n rise=100p fall=100p width=2n period=200n
C_P_3_3_0 (mem_p_3_3_0 0) capacitor c=cmul
R_P_3_3_0 (mem_p_3_3_0 0) resistor r=rmul
MP_P_3_3_0_1 (p_3_3_0_n mem_p_3_3_0 vdd vdd) pch_cmp w=2u l=1u
MN_P_3_3_0_1 (p_3_3_0_n mem_p_3_3_0 0 0) nch_cmp w=1u l=1u
MP_P_3_3_0_2 (p_3_3_0 p_3_3_0_n vdd vdd) pch w=2u l=1u
MN_P_3_3_0_2 (p_3_3_0 p_3_3_0_n 0 0) nch w=1u l=1u

// p_3_3_1 = a31 * b13
I_P_3_3_1_A (vdd mem_p_3_3_1) isource type=pulse val0=0 val1=a31*iin_amp delay=10n rise=100p fall=100p width=2n period=200n
I_P_3_3_1_B (vdd mem_p_3_3_1) isource type=pulse val0=0 val1=b13*iin_amp delay=10n rise=100p fall=100p width=2n period=200n
C_P_3_3_1 (mem_p_3_3_1 0) capacitor c=cmul
R_P_3_3_1 (mem_p_3_3_1 0) resistor r=rmul
MP_P_3_3_1_1 (p_3_3_1_n mem_p_3_3_1 vdd vdd) pch_cmp w=2u l=1u
MN_P_3_3_1_1 (p_3_3_1_n mem_p_3_3_1 0 0) nch_cmp w=1u l=1u
MP_P_3_3_1_2 (p_3_3_1 p_3_3_1_n vdd vdd) pch w=2u l=1u
MN_P_3_3_1_2 (p_3_3_1 p_3_3_1_n 0 0) nch w=1u l=1u

// p_3_3_2 = a32 * b23
I_P_3_3_2_A (vdd mem_p_3_3_2) isource type=pulse val0=0 val1=a32*iin_amp delay=10n rise=100p fall=100p width=2n period=200n
I_P_3_3_2_B (vdd mem_p_3_3_2) isource type=pulse val0=0 val1=b23*iin_amp delay=10n rise=100p fall=100p width=2n period=200n
C_P_3_3_2 (mem_p_3_3_2 0) capacitor c=cmul
R_P_3_3_2 (mem_p_3_3_2 0) resistor r=rmul
MP_P_3_3_2_1 (p_3_3_2_n mem_p_3_3_2 vdd vdd) pch_cmp w=2u l=1u
MN_P_3_3_2_1 (p_3_3_2_n mem_p_3_3_2 0 0) nch_cmp w=1u l=1u
MP_P_3_3_2_2 (p_3_3_2 p_3_3_2_n vdd vdd) pch w=2u l=1u
MN_P_3_3_2_2 (p_3_3_2 p_3_3_2_n 0 0) nch w=1u l=1u

// p_3_3_3 = a33 * b33
I_P_3_3_3_A (vdd mem_p_3_3_3) isource type=pulse val0=0 val1=a33*iin_amp delay=10n rise=100p fall=100p width=2n period=200n
I_P_3_3_3_B (vdd mem_p_3_3_3) isource type=pulse val0=0 val1=b33*iin_amp delay=10n rise=100p fall=100p width=2n period=200n
C_P_3_3_3 (mem_p_3_3_3 0) capacitor c=cmul
R_P_3_3_3 (mem_p_3_3_3 0) resistor r=rmul
MP_P_3_3_3_1 (p_3_3_3_n mem_p_3_3_3 vdd vdd) pch_cmp w=2u l=1u
MN_P_3_3_3_1 (p_3_3_3_n mem_p_3_3_3 0 0) nch_cmp w=1u l=1u
MP_P_3_3_3_2 (p_3_3_3 p_3_3_3_n vdd vdd) pch w=2u l=1u
MN_P_3_3_3_2 (p_3_3_3 p_3_3_3_n 0 0) nch w=1u l=1u

// Output accumulation membranes: yij = sum_k p_ij_k
R_P_0_0_0_Y (p_0_0_0 y00_mem) resistor r=rsum_in
R_P_0_0_1_Y (p_0_0_1 y00_mem) resistor r=rsum_in
R_P_0_0_2_Y (p_0_0_2 y00_mem) resistor r=rsum_in
R_P_0_0_3_Y (p_0_0_3 y00_mem) resistor r=rsum_in
C_Y00 (y00_mem 0) capacitor c=csum
R_Y00_LEAK (y00_mem 0) resistor r=rsum_leak

R_P_0_1_0_Y (p_0_1_0 y01_mem) resistor r=rsum_in
R_P_0_1_1_Y (p_0_1_1 y01_mem) resistor r=rsum_in
R_P_0_1_2_Y (p_0_1_2 y01_mem) resistor r=rsum_in
R_P_0_1_3_Y (p_0_1_3 y01_mem) resistor r=rsum_in
C_Y01 (y01_mem 0) capacitor c=csum
R_Y01_LEAK (y01_mem 0) resistor r=rsum_leak

R_P_0_2_0_Y (p_0_2_0 y02_mem) resistor r=rsum_in
R_P_0_2_1_Y (p_0_2_1 y02_mem) resistor r=rsum_in
R_P_0_2_2_Y (p_0_2_2 y02_mem) resistor r=rsum_in
R_P_0_2_3_Y (p_0_2_3 y02_mem) resistor r=rsum_in
C_Y02 (y02_mem 0) capacitor c=csum
R_Y02_LEAK (y02_mem 0) resistor r=rsum_leak

R_P_0_3_0_Y (p_0_3_0 y03_mem) resistor r=rsum_in
R_P_0_3_1_Y (p_0_3_1 y03_mem) resistor r=rsum_in
R_P_0_3_2_Y (p_0_3_2 y03_mem) resistor r=rsum_in
R_P_0_3_3_Y (p_0_3_3 y03_mem) resistor r=rsum_in
C_Y03 (y03_mem 0) capacitor c=csum
R_Y03_LEAK (y03_mem 0) resistor r=rsum_leak

R_P_1_0_0_Y (p_1_0_0 y10_mem) resistor r=rsum_in
R_P_1_0_1_Y (p_1_0_1 y10_mem) resistor r=rsum_in
R_P_1_0_2_Y (p_1_0_2 y10_mem) resistor r=rsum_in
R_P_1_0_3_Y (p_1_0_3 y10_mem) resistor r=rsum_in
C_Y10 (y10_mem 0) capacitor c=csum
R_Y10_LEAK (y10_mem 0) resistor r=rsum_leak

R_P_1_1_0_Y (p_1_1_0 y11_mem) resistor r=rsum_in
R_P_1_1_1_Y (p_1_1_1 y11_mem) resistor r=rsum_in
R_P_1_1_2_Y (p_1_1_2 y11_mem) resistor r=rsum_in
R_P_1_1_3_Y (p_1_1_3 y11_mem) resistor r=rsum_in
C_Y11 (y11_mem 0) capacitor c=csum
R_Y11_LEAK (y11_mem 0) resistor r=rsum_leak

R_P_1_2_0_Y (p_1_2_0 y12_mem) resistor r=rsum_in
R_P_1_2_1_Y (p_1_2_1 y12_mem) resistor r=rsum_in
R_P_1_2_2_Y (p_1_2_2 y12_mem) resistor r=rsum_in
R_P_1_2_3_Y (p_1_2_3 y12_mem) resistor r=rsum_in
C_Y12 (y12_mem 0) capacitor c=csum
R_Y12_LEAK (y12_mem 0) resistor r=rsum_leak

R_P_1_3_0_Y (p_1_3_0 y13_mem) resistor r=rsum_in
R_P_1_3_1_Y (p_1_3_1 y13_mem) resistor r=rsum_in
R_P_1_3_2_Y (p_1_3_2 y13_mem) resistor r=rsum_in
R_P_1_3_3_Y (p_1_3_3 y13_mem) resistor r=rsum_in
C_Y13 (y13_mem 0) capacitor c=csum
R_Y13_LEAK (y13_mem 0) resistor r=rsum_leak

R_P_2_0_0_Y (p_2_0_0 y20_mem) resistor r=rsum_in
R_P_2_0_1_Y (p_2_0_1 y20_mem) resistor r=rsum_in
R_P_2_0_2_Y (p_2_0_2 y20_mem) resistor r=rsum_in
R_P_2_0_3_Y (p_2_0_3 y20_mem) resistor r=rsum_in
C_Y20 (y20_mem 0) capacitor c=csum
R_Y20_LEAK (y20_mem 0) resistor r=rsum_leak

R_P_2_1_0_Y (p_2_1_0 y21_mem) resistor r=rsum_in
R_P_2_1_1_Y (p_2_1_1 y21_mem) resistor r=rsum_in
R_P_2_1_2_Y (p_2_1_2 y21_mem) resistor r=rsum_in
R_P_2_1_3_Y (p_2_1_3 y21_mem) resistor r=rsum_in
C_Y21 (y21_mem 0) capacitor c=csum
R_Y21_LEAK (y21_mem 0) resistor r=rsum_leak

R_P_2_2_0_Y (p_2_2_0 y22_mem) resistor r=rsum_in
R_P_2_2_1_Y (p_2_2_1 y22_mem) resistor r=rsum_in
R_P_2_2_2_Y (p_2_2_2 y22_mem) resistor r=rsum_in
R_P_2_2_3_Y (p_2_2_3 y22_mem) resistor r=rsum_in
C_Y22 (y22_mem 0) capacitor c=csum
R_Y22_LEAK (y22_mem 0) resistor r=rsum_leak

R_P_2_3_0_Y (p_2_3_0 y23_mem) resistor r=rsum_in
R_P_2_3_1_Y (p_2_3_1 y23_mem) resistor r=rsum_in
R_P_2_3_2_Y (p_2_3_2 y23_mem) resistor r=rsum_in
R_P_2_3_3_Y (p_2_3_3 y23_mem) resistor r=rsum_in
C_Y23 (y23_mem 0) capacitor c=csum
R_Y23_LEAK (y23_mem 0) resistor r=rsum_leak

R_P_3_0_0_Y (p_3_0_0 y30_mem) resistor r=rsum_in
R_P_3_0_1_Y (p_3_0_1 y30_mem) resistor r=rsum_in
R_P_3_0_2_Y (p_3_0_2 y30_mem) resistor r=rsum_in
R_P_3_0_3_Y (p_3_0_3 y30_mem) resistor r=rsum_in
C_Y30 (y30_mem 0) capacitor c=csum
R_Y30_LEAK (y30_mem 0) resistor r=rsum_leak

R_P_3_1_0_Y (p_3_1_0 y31_mem) resistor r=rsum_in
R_P_3_1_1_Y (p_3_1_1 y31_mem) resistor r=rsum_in
R_P_3_1_2_Y (p_3_1_2 y31_mem) resistor r=rsum_in
R_P_3_1_3_Y (p_3_1_3 y31_mem) resistor r=rsum_in
C_Y31 (y31_mem 0) capacitor c=csum
R_Y31_LEAK (y31_mem 0) resistor r=rsum_leak

R_P_3_2_0_Y (p_3_2_0 y32_mem) resistor r=rsum_in
R_P_3_2_1_Y (p_3_2_1 y32_mem) resistor r=rsum_in
R_P_3_2_2_Y (p_3_2_2 y32_mem) resistor r=rsum_in
R_P_3_2_3_Y (p_3_2_3 y32_mem) resistor r=rsum_in
C_Y32 (y32_mem 0) capacitor c=csum
R_Y32_LEAK (y32_mem 0) resistor r=rsum_leak

R_P_3_3_0_Y (p_3_3_0 y33_mem) resistor r=rsum_in
R_P_3_3_1_Y (p_3_3_1 y33_mem) resistor r=rsum_in
R_P_3_3_2_Y (p_3_3_2 y33_mem) resistor r=rsum_in
R_P_3_3_3_Y (p_3_3_3 y33_mem) resistor r=rsum_in
C_Y33 (y33_mem 0) capacitor c=csum
R_Y33_LEAK (y33_mem 0) resistor r=rsum_leak

tran_test tran stop=120n
save p_0_0_0 p_0_0_1 p_0_0_2 p_0_0_3 p_0_1_0 p_0_1_1 p_0_1_2 p_0_1_3 p_0_2_0 p_0_2_1 p_0_2_2 p_0_2_3 p_0_3_0 p_0_3_1 p_0_3_2 p_0_3_3 p_1_0_0 p_1_0_1 p_1_0_2 p_1_0_3 p_1_1_0 p_1_1_1 p_1_1_2 p_1_1_3 p_1_2_0 p_1_2_1 p_1_2_2 p_1_2_3 p_1_3_0 p_1_3_1 p_1_3_2 p_1_3_3 p_2_0_0 p_2_0_1 p_2_0_2 p_2_0_3 p_2_1_0 p_2_1_1 p_2_1_2 p_2_1_3 p_2_2_0 p_2_2_1 p_2_2_2 p_2_2_3 p_2_3_0 p_2_3_1 p_2_3_2 p_2_3_3 p_3_0_0 p_3_0_1 p_3_0_2 p_3_0_3 p_3_1_0 p_3_1_1 p_3_1_2 p_3_1_3 p_3_2_0 p_3_2_1 p_3_2_2 p_3_2_3 p_3_3_0 p_3_3_1 p_3_3_2 p_3_3_3 y00_mem y01_mem y02_mem y03_mem y10_mem y11_mem y12_mem y13_mem y20_mem y21_mem y22_mem y23_mem y30_mem y31_mem y32_mem y33_mem V_VDD:p
