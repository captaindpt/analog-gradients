// nor2.scs - 2-input CMOS NOR Gate
// Truth table: OUT = ~(A | B)
//   A B | OUT
//   0 0 | 1
//   0 1 | 0
//   1 0 | 0
//   1 1 | 0
// Run: spectre nor2.scs -raw nor2.raw

simulator lang=spectre

parameters vdd_val=1.8

// MOSFET Models
model nch mos1 type=n vto=0.4 kp=120u
model pch mos1 type=p vto=-0.4 kp=40u

// Supply
V_VDD (vdd 0) vsource dc=vdd_val

// Inputs - same pattern as NAND2
// t=5ns:  A=0, B=0 -> OUT=1
// t=15ns: A=1, B=0 -> OUT=0
// t=25ns: A=0, B=1 -> OUT=0
// t=35ns: A=1, B=1 -> OUT=0
V_A (a 0) vsource type=pulse val0=0 val1=vdd_val delay=10n rise=100p fall=100p width=10n period=20n
V_B (b 0) vsource type=pulse val0=0 val1=vdd_val delay=20n rise=100p fall=100p width=20n period=40n

// NOR2 Gate
// Series PMOS (pull-up) - both A AND B LOW needed to pull up
// Wider channel for series resistance
MP0 (mid a vdd vdd) pch w=4u l=1u
MP1 (out b mid mid) pch w=4u l=1u

// Parallel NMOS (pull-down) - either A or B HIGH pulls down
MN0 (out a 0 0) nch w=1u l=1u
MN1 (out b 0 0) nch w=1u l=1u

// Analysis
tran_test tran stop=80n

save out a b
