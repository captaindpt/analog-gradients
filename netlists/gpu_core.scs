// gpu_core.scs - GPU-Lite core (PE4 wrapper)
// Shared opcode, 4 PEs, 4-bit each
// Run: spectre gpu_core.scs -raw gpu_core.raw

simulator lang=spectre

parameters vdd_val=1.8

// MOSFET Models
model nch mos1 type=n vth=0.4 kp=120u
model pch mos1 type=p vth=-0.4 kp=40u

// Supply
V_VDD (vdd 0) vsource dc=vdd_val

// Shared opcode
V_OP0 (op0 0) vsource type=pwl wave=[0 0   9.9n 0   10n 1.8 19.9n 1.8 20n 0   29.9n 0   30n 1.8 39.9n 1.8 40n 1.8]
V_OP1 (op1 0) vsource type=pwl wave=[0 0   9.9n 0   10n 0   19.9n 0   20n 1.8 29.9n 1.8 30n 1.8 39.9n 1.8 40n 1.8]

// PE0 vectors (same as ALU4)
V_A0_0 (a0_0 0) vsource type=pwl wave=[0 1.8 9.9n 1.8 10n 0   19.9n 0   20n 0   29.9n 0   30n 1.8 39.9n 1.8 40n 1.8]
V_A0_1 (a0_1 0) vsource type=pwl wave=[0 0   9.9n 0   10n 1.8 19.9n 1.8 20n 1.8 29.9n 1.8 30n 1.8 39.9n 1.8 40n 1.8]
V_A0_2 (a0_2 0) vsource type=pwl wave=[0 1.8 9.9n 1.8 10n 0   19.9n 0   20n 1.8 29.9n 1.8 30n 1.8 39.9n 1.8 40n 1.8]
V_A0_3 (a0_3 0) vsource type=pwl wave=[0 0   9.9n 0   10n 1.8 19.9n 1.8 20n 0   29.9n 0   30n 1.8 39.9n 1.8 40n 1.8]

V_B0_0 (b0_0 0) vsource type=pwl wave=[0 1.8 9.9n 1.8 10n 0   19.9n 0   20n 1.8 29.9n 1.8 30n 1.8 39.9n 1.8 40n 1.8]
V_B0_1 (b0_1 0) vsource type=pwl wave=[0 1.8 9.9n 1.8 10n 0   19.9n 0   20n 0   29.9n 0   30n 0   39.9n 0   40n 0  ]
V_B0_2 (b0_2 0) vsource type=pwl wave=[0 0   9.9n 0   10n 1.8 19.9n 1.8 20n 0   29.9n 0   30n 0   39.9n 0   40n 0  ]
V_B0_3 (b0_3 0) vsource type=pwl wave=[0 0   9.9n 0   10n 0   19.9n 0   20n 1.8 29.9n 1.8 30n 0   39.9n 0   40n 0  ]

// PE1 vectors (shifted patterns)
V_A1_0 (a1_0 0) vsource type=pwl wave=[0 0   9.9n 0   10n 1.8 19.9n 1.8 20n 0   29.9n 0   30n 0   39.9n 0   40n 0  ]
V_A1_1 (a1_1 0) vsource type=pwl wave=[0 1.8 9.9n 1.8 10n 0   19.9n 0   20n 1.8 29.9n 1.8 30n 0   39.9n 0   40n 0  ]
V_A1_2 (a1_2 0) vsource type=pwl wave=[0 0   9.9n 0   10n 1.8 19.9n 1.8 20n 0   29.9n 0   30n 1.8 39.9n 1.8 40n 1.8]
V_A1_3 (a1_3 0) vsource type=pwl wave=[0 1.8 9.9n 1.8 10n 0   19.9n 0   20n 0   29.9n 0   30n 1.8 39.9n 1.8 40n 1.8]

V_B1_0 (b1_0 0) vsource type=pwl wave=[0 1.8 9.9n 1.8 10n 1.8 19.9n 1.8 20n 0   29.9n 0   30n 1.8 39.9n 1.8 40n 1.8]
V_B1_1 (b1_1 0) vsource type=pwl wave=[0 0   9.9n 0   10n 1.8 19.9n 1.8 20n 1.8 29.9n 1.8 30n 0   39.9n 0   40n 0  ]
V_B1_2 (b1_2 0) vsource type=pwl wave=[0 0   9.9n 0   10n 0   19.9n 0   20n 1.8 29.9n 1.8 30n 1.8 39.9n 1.8 40n 1.8]
V_B1_3 (b1_3 0) vsource type=pwl wave=[0 1.8 9.9n 1.8 10n 0   19.9n 0   20n 0   29.9n 0   30n 0   39.9n 0   40n 0  ]

// PE2 vectors (another pattern set)
V_A2_0 (a2_0 0) vsource type=pwl wave=[0 1.8 9.9n 1.8 10n 1.8 19.9n 1.8 20n 0   29.9n 0   30n 0   39.9n 0   40n 0  ]
V_A2_1 (a2_1 0) vsource type=pwl wave=[0 0   9.9n 0   10n 1.8 19.9n 1.8 20n 0   29.9n 0   30n 1.8 39.9n 1.8 40n 1.8]
V_A2_2 (a2_2 0) vsource type=pwl wave=[0 1.8 9.9n 1.8 10n 0   19.9n 0   20n 1.8 29.9n 1.8 30n 0   39.9n 0   40n 0  ]
V_A2_3 (a2_3 0) vsource type=pwl wave=[0 0   9.9n 0   10n 0   19.9n 0   20n 1.8 29.9n 1.8 30n 1.8 39.9n 1.8 40n 1.8]

V_B2_0 (b2_0 0) vsource type=pwl wave=[0 0   9.9n 0   10n 1.8 19.9n 1.8 20n 1.8 29.9n 1.8 30n 0   39.9n 0   40n 0  ]
V_B2_1 (b2_1 0) vsource type=pwl wave=[0 1.8 9.9n 1.8 10n 0   19.9n 0   20n 1.8 29.9n 1.8 30n 1.8 39.9n 1.8 40n 1.8]
V_B2_2 (b2_2 0) vsource type=pwl wave=[0 1.8 9.9n 1.8 10n 1.8 19.9n 1.8 20n 0   29.9n 0   30n 0   39.9n 0   40n 0  ]
V_B2_3 (b2_3 0) vsource type=pwl wave=[0 0   9.9n 0   10n 0   19.9n 0   20n 1.8 29.9n 1.8 30n 1.8 39.9n 1.8 40n 1.8]

// PE3 vectors (final pattern set)
V_A3_0 (a3_0 0) vsource type=pwl wave=[0 0   9.9n 0   10n 0   19.9n 0   20n 1.8 29.9n 1.8 30n 1.8 39.9n 1.8 40n 1.8]
V_A3_1 (a3_1 0) vsource type=pwl wave=[0 1.8 9.9n 1.8 10n 1.8 19.9n 1.8 20n 0   29.9n 0   30n 0   39.9n 0   40n 0  ]
V_A3_2 (a3_2 0) vsource type=pwl wave=[0 0   9.9n 0   10n 1.8 19.9n 1.8 20n 1.8 29.9n 1.8 30n 0   39.9n 0   40n 0  ]
V_A3_3 (a3_3 0) vsource type=pwl wave=[0 1.8 9.9n 1.8 10n 0   19.9n 0   20n 1.8 29.9n 1.8 30n 1.8 39.9n 1.8 40n 1.8]

V_B3_0 (b3_0 0) vsource type=pwl wave=[0 1.8 9.9n 1.8 10n 0   19.9n 0   20n 0   29.9n 0   30n 1.8 39.9n 1.8 40n 1.8]
V_B3_1 (b3_1 0) vsource type=pwl wave=[0 0   9.9n 0   10n 1.8 19.9n 1.8 20n 0   29.9n 0   30n 1.8 39.9n 1.8 40n 1.8]
V_B3_2 (b3_2 0) vsource type=pwl wave=[0 1.8 9.9n 1.8 10n 1.8 19.9n 1.8 20n 1.8 29.9n 1.8 30n 0   39.9n 0   40n 0  ]
V_B3_3 (b3_3 0) vsource type=pwl wave=[0 0   9.9n 0   10n 0   19.9n 0   20n 1.8 29.9n 1.8 30n 0   39.9n 0   40n 0  ]

// CIN held low for each PE
V_CIN0 (cin0 0) vsource dc=0
V_CIN1 (cin1 0) vsource dc=0
V_CIN2 (cin2 0) vsource dc=0
V_CIN3 (cin3 0) vsource dc=0

// Subcircuits (reuse from PE4)
subckt inverter (in out vdd)
    MP0 (out in vdd vdd) pch w=2u l=1u
    MN0 (out in 0 0) nch w=1u l=1u
ends inverter

subckt nand2 (a b out vdd)
    MP0 (out a vdd vdd) pch w=2u l=1u
    MP1 (out b vdd vdd) pch w=2u l=1u
    MN0 (out a mid 0) nch w=2u l=1u
    MN1 (mid b 0 0) nch w=2u l=1u
ends nand2

subckt nor2 (a b out vdd)
    MP0 (mid a vdd vdd) pch w=4u l=1u
    MP1 (out b mid mid) pch w=4u l=1u
    MN0 (out a 0 0) nch w=1u l=1u
    MN1 (out b 0 0) nch w=1u l=1u
ends nor2

subckt and2 (a b out vdd)
    X_NAND (a b n_out vdd) nand2
    X_INV (n_out out vdd) inverter
ends and2

subckt or2 (a b out vdd)
    X_NOR (a b n_out vdd) nor2
    X_INV (n_out out vdd) inverter
ends or2

subckt xor2 (a b out vdd)
    X_N1 (a b n1 vdd) nand2
    X_N2 (a n1 n2 vdd) nand2
    X_N3 (b n1 n3 vdd) nand2
    X_N4 (n2 n3 out vdd) nand2
ends xor2

subckt mux2 (a b s out vdd)
    X_INV (s s_n vdd) inverter
    X_AND0 (a s_n a_and vdd) and2
    X_AND1 (b s b_and vdd) and2
    X_OR (a_and b_and out vdd) or2
ends mux2

subckt full_adder (a b cin sum cout vdd)
    X_X1 (a b axb vdd) xor2
    X_X2 (axb cin sum vdd) xor2
    X_A1 (a b a_and_b vdd) and2
    X_A2 (cin axb c_and_axb vdd) and2
    X_OR (a_and_b c_and_axb cout vdd) or2
ends full_adder

subckt alu1 (a b cin op0 op1 y cout vdd)
    X_AND (a b and_out vdd) and2
    X_OR  (a b or_out vdd)  or2
    X_XOR (a b xor_out vdd) xor2
    X_ADD (a b cin sum_out cout vdd) full_adder

    X_M0 (and_out or_out op0 m0 vdd) mux2
    X_M1 (xor_out sum_out op0 m1 vdd) mux2
    X_M2 (m0 m1 op1 y vdd) mux2
ends alu1

subckt alu4 (a0 a1 a2 a3 b0 b1 b2 b3 cin op0 op1 y0 y1 y2 y3 cout vdd)
    X0 (a0 b0 cin op0 op1 y0 c1 vdd) alu1
    X1 (a1 b1 c1  op0 op1 y1 c2 vdd) alu1
    X2 (a2 b2 c2  op0 op1 y2 c3 vdd) alu1
    X3 (a3 b3 c3  op0 op1 y3 cout vdd) alu1
ends alu4

subckt pe1 (a0 a1 a2 a3 b0 b1 b2 b3 cin op0 op1 y0 y1 y2 y3 cout vdd)
    X_ALU (a0 a1 a2 a3 b0 b1 b2 b3 cin op0 op1 y0 y1 y2 y3 cout vdd) alu4
ends pe1

subckt pe4 (op0 op1
            a0_0 a0_1 a0_2 a0_3 b0_0 b0_1 b0_2 b0_3
            a1_0 a1_1 a1_2 a1_3 b1_0 b1_1 b1_2 b1_3
            a2_0 a2_1 a2_2 a2_3 b2_0 b2_1 b2_2 b2_3
            a3_0 a3_1 a3_2 a3_3 b3_0 b3_1 b3_2 b3_3
            y0_0 y0_1 y0_2 y0_3 y1_0 y1_1 y1_2 y1_3 y2_0 y2_1 y2_2 y2_3 y3_0 y3_1 y3_2 y3_3
            cout0 cout1 cout2 cout3 vdd)
    X_PE0 (a0_0 a0_1 a0_2 a0_3 b0_0 b0_1 b0_2 b0_3 cin0 op0 op1 y0_0 y0_1 y0_2 y0_3 cout0 vdd) pe1
    X_PE1 (a1_0 a1_1 a1_2 a1_3 b1_0 b1_1 b1_2 b1_3 cin1 op0 op1 y1_0 y1_1 y1_2 y1_3 cout1 vdd) pe1
    X_PE2 (a2_0 a2_1 a2_2 a2_3 b2_0 b2_1 b2_2 b2_3 cin2 op0 op1 y2_0 y2_1 y2_2 y2_3 cout2 vdd) pe1
    X_PE3 (a3_0 a3_1 a3_2 a3_3 b3_0 b3_1 b3_2 b3_3 cin3 op0 op1 y3_0 y3_1 y3_2 y3_3 cout3 vdd) pe1
ends pe4

subckt gpu_core (op0 op1
                 a0_0 a0_1 a0_2 a0_3 b0_0 b0_1 b0_2 b0_3
                 a1_0 a1_1 a1_2 a1_3 b1_0 b1_1 b1_2 b1_3
                 a2_0 a2_1 a2_2 a2_3 b2_0 b2_1 b2_2 b2_3
                 a3_0 a3_1 a3_2 a3_3 b3_0 b3_1 b3_2 b3_3
                 y0_0 y0_1 y0_2 y0_3 y1_0 y1_1 y1_2 y1_3 y2_0 y2_1 y2_2 y2_3 y3_0 y3_1 y3_2 y3_3
                 cout0 cout1 cout2 cout3 vdd)
    X_PE4 (op0 op1
           a0_0 a0_1 a0_2 a0_3 b0_0 b0_1 b0_2 b0_3
           a1_0 a1_1 a1_2 a1_3 b1_0 b1_1 b1_2 b1_3
           a2_0 a2_1 a2_2 a2_3 b2_0 b2_1 b2_2 b2_3
           a3_0 a3_1 a3_2 a3_3 b3_0 b3_1 b3_2 b3_3
           y0_0 y0_1 y0_2 y0_3 y1_0 y1_1 y1_2 y1_3 y2_0 y2_1 y2_2 y2_3 y3_0 y3_1 y3_2 y3_3
           cout0 cout1 cout2 cout3 vdd) pe4
ends gpu_core

// GPU core
X_GPU (op0 op1
       a0_0 a0_1 a0_2 a0_3 b0_0 b0_1 b0_2 b0_3
       a1_0 a1_1 a1_2 a1_3 b1_0 b1_1 b1_2 b1_3
       a2_0 a2_1 a2_2 a2_3 b2_0 b2_1 b2_2 b2_3
       a3_0 a3_1 a3_2 a3_3 b3_0 b3_1 b3_2 b3_3
       y0_0 y0_1 y0_2 y0_3 y1_0 y1_1 y1_2 y1_3 y2_0 y2_1 y2_2 y2_3 y3_0 y3_1 y3_2 y3_3
       cout0 cout1 cout2 cout3 vdd) gpu_core

// Analysis
tran_test tran stop=45n

save y0_0 y0_1 y0_2 y0_3 y1_0 y1_1 y1_2 y1_3 y2_0 y2_1 y2_2 y2_3 y3_0 y3_1 y3_2 y3_3 cout0 cout1 cout2 cout3
