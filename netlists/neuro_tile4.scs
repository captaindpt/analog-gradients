// neuro_tile4.scs - 4-neuron neuromorphic composition tile
// Run: spectre neuro_tile4.scs -raw neuro_tile4.raw

simulator lang=spectre

parameters vdd_val=1.8 cpost=200f rdecay=80k r_couple=8k cmem=500f rleak=8M

model nch mos1 type=n vth=0.4 kp=120u
model pch mos1 type=p vth=-0.4 kp=40u

V_VDD (vdd 0) vsource dc=vdd_val

// Staggered presynaptic drives for four channels
V_PRE0 (pre0 0) vsource type=pulse val0=0 val1=vdd_val \
    delay=5n rise=100p fall=100p width=2n period=20n
V_PRE1 (pre1 0) vsource type=pulse val0=0 val1=vdd_val \
    delay=7n rise=100p fall=100p width=2n period=20n
V_PRE2 (pre2 0) vsource type=pulse val0=0 val1=vdd_val \
    delay=9n rise=100p fall=100p width=2n period=20n
V_PRE3 (pre3 0) vsource type=pulse val0=0 val1=vdd_val \
    delay=11n rise=100p fall=100p width=2n period=20n

// Neuron 0: synapse -> membrane -> spike
MN_SYN0 (syn0 pre0 vdd 0) nch w=4u l=1u
C_SYN0 (syn0 0) capacitor c=cpost
R_SYN0 (syn0 0) resistor r=rdecay
R_COUPLE0 (syn0 mem0) resistor r=r_couple
C_MEM0 (mem0 0) capacitor c=cmem
R_LEAK0 (mem0 0) resistor r=rleak
MP0A (spike0_n mem0 vdd vdd) pch w=2u l=1u
MN0A (spike0_n mem0 0 0) nch w=1u l=1u
MP0B (spike0 spike0_n vdd vdd) pch w=2u l=1u
MN0B (spike0 spike0_n 0 0) nch w=1u l=1u
MN_RST0 (mem0 spike0 0 0) nch w=700n l=1u

// Neuron 1
MN_SYN1 (syn1 pre1 vdd 0) nch w=4u l=1u
C_SYN1 (syn1 0) capacitor c=cpost
R_SYN1 (syn1 0) resistor r=rdecay
R_COUPLE1 (syn1 mem1) resistor r=r_couple
C_MEM1 (mem1 0) capacitor c=cmem
R_LEAK1 (mem1 0) resistor r=rleak
MP1A (spike1_n mem1 vdd vdd) pch w=2u l=1u
MN1A (spike1_n mem1 0 0) nch w=1u l=1u
MP1B (spike1 spike1_n vdd vdd) pch w=2u l=1u
MN1B (spike1 spike1_n 0 0) nch w=1u l=1u
MN_RST1 (mem1 spike1 0 0) nch w=700n l=1u

// Neuron 2
MN_SYN2 (syn2 pre2 vdd 0) nch w=4u l=1u
C_SYN2 (syn2 0) capacitor c=cpost
R_SYN2 (syn2 0) resistor r=rdecay
R_COUPLE2 (syn2 mem2) resistor r=r_couple
C_MEM2 (mem2 0) capacitor c=cmem
R_LEAK2 (mem2 0) resistor r=rleak
MP2A (spike2_n mem2 vdd vdd) pch w=2u l=1u
MN2A (spike2_n mem2 0 0) nch w=1u l=1u
MP2B (spike2 spike2_n vdd vdd) pch w=2u l=1u
MN2B (spike2 spike2_n 0 0) nch w=1u l=1u
MN_RST2 (mem2 spike2 0 0) nch w=700n l=1u

// Neuron 3
MN_SYN3 (syn3 pre3 vdd 0) nch w=4u l=1u
C_SYN3 (syn3 0) capacitor c=cpost
R_SYN3 (syn3 0) resistor r=rdecay
R_COUPLE3 (syn3 mem3) resistor r=r_couple
C_MEM3 (mem3 0) capacitor c=cmem
R_LEAK3 (mem3 0) resistor r=rleak
MP3A (spike3_n mem3 vdd vdd) pch w=2u l=1u
MN3A (spike3_n mem3 0 0) nch w=1u l=1u
MP3B (spike3 spike3_n vdd vdd) pch w=2u l=1u
MN3B (spike3 spike3_n 0 0) nch w=1u l=1u
MN_RST3 (mem3 spike3 0 0) nch w=700n l=1u

tran_test tran stop=300n
save pre0 pre1 pre2 pre3 syn0 syn1 syn2 syn3 mem0 mem1 mem2 mem3 spike0 spike1 spike2 spike3
