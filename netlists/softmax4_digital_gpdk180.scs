// softmax4_digital_gpdk180.scs - GPDK180-compatible digital softmax proxy
// NOTE: Behavioral outputs; power modeled by idigital current source.

simulator lang=spectre
global 0

parameters vdd_val=1.8
parameters in0=0 in1=0 in2=0 in3=0
parameters kexp=2.0 eps=1e-12
parameters idigital=100u

include "/CMC/kits/cadence/GPDK180/gpdk180_v3.3/models/spectre/gpdk.scs" section=NN

V_VDD (vdd 0) vsource dc=vdd_val

// Input voltages (logits)
V_IN0 (vin0 0) vsource dc=in0
V_IN1 (vin1 0) vsource dc=in1
V_IN2 (vin2 0) vsource dc=in2
V_IN3 (vin3 0) vsource dc=in3

// Proxy for digital compute power
I_DIG (vdd 0) isource dc=idigital

// Behavioral softmax outputs
BOUT0 (out0 0) bsource v=exp(kexp*V(vin0))/(exp(kexp*V(vin0))+exp(kexp*V(vin1))+exp(kexp*V(vin2))+exp(kexp*V(vin3))+eps)
BOUT1 (out1 0) bsource v=exp(kexp*V(vin1))/(exp(kexp*V(vin0))+exp(kexp*V(vin1))+exp(kexp*V(vin2))+exp(kexp*V(vin3))+eps)
BOUT2 (out2 0) bsource v=exp(kexp*V(vin2))/(exp(kexp*V(vin0))+exp(kexp*V(vin1))+exp(kexp*V(vin2))+exp(kexp*V(vin3))+eps)
BOUT3 (out3 0) bsource v=exp(kexp*V(vin3))/(exp(kexp*V(vin0))+exp(kexp*V(vin1))+exp(kexp*V(vin2))+exp(kexp*V(vin3))+eps)

C0 (out0 0) capacitor c=1p
C1 (out1 0) capacitor c=1p
C2 (out2 0) capacitor c=1p
C3 (out3 0) capacitor c=1p

tran_test tran stop=50n
save vin0 vin1 vin2 vin3 out0 out1 out2 out3 vdd V_VDD:p
