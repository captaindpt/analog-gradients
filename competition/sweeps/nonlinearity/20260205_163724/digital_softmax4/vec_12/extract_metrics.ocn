; auto-generated nonlinearity metrics extraction
out = outfile("/home/v71349/analog-gradients/competition/sweeps/nonlinearity/20260205_163724/digital_softmax4/vec_12/metrics.txt" "w")

simulator('spectre)
openResults("/home/v71349/analog-gradients/competition/sweeps/nonlinearity/20260205_163724/digital_softmax4/vec_12/softmax4_digital_gpdk180.raw")
selectResult("tran_test-tran")

vraw0 = v("out0")
vraw1 = v("out1")
vraw2 = v("out2")
vraw3 = v("out3")
idd = getData("V_VDD:p")
vvdd = v("vdd")

if(vraw0 && vraw1 && vraw2 && vraw3 && idd && vvdd then
  dt = 100.0p
  t_start = 0.0n
  t_stop = 50.0n
  t_eval = 50.0n

  scale = 1.0
  offset = 0.0
  vout0 = scale * (vraw0 - offset)
  vout1 = scale * (vraw1 - offset)
  vout2 = scale * (vraw2 - offset)
  vout3 = scale * (vraw3 - offset)

  energy = 0
  ts = t_start
  prev_i = value(idd ts)
  prev_v = value(vvdd ts)
  prev_t = ts
  ts = ts + dt
  while(ts <= t_stop
    curr_i = value(idd ts)
    curr_v = value(vvdd ts)
    p0 = -prev_i * prev_v
    p1 = -curr_i * curr_v
    energy = energy + 0.5 * (p0 + p1) * (ts - prev_t)
    prev_i = curr_i
    prev_v = curr_v
    prev_t = ts
    ts = ts + dt
  )

  fprintf(out "status=OK\n")
  fprintf(out "raw0=%.9f\n" value(vraw0 t_eval))
  fprintf(out "out0=%.9f\n" value(vout0 t_eval))
  fprintf(out "raw1=%.9f\n" value(vraw1 t_eval))
  fprintf(out "out1=%.9f\n" value(vout1 t_eval))
  fprintf(out "raw2=%.9f\n" value(vraw2 t_eval))
  fprintf(out "out2=%.9f\n" value(vout2 t_eval))
  fprintf(out "raw3=%.9f\n" value(vraw3 t_eval))
  fprintf(out "out3=%.9f\n" value(vout3 t_eval))

  fprintf(out "energy_j=%.12e\n" energy)
else
  fprintf(out "status=ERROR\n")
)

close(out)
exit()
